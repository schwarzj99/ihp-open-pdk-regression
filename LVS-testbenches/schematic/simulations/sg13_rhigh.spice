** sch_path: /foss/designs/ihp-open-pdk-regression/LVS-testbenches/schematic/sg13_rhigh.sch
.subckt sg13_rhigh R0 R1
*.PININFO R0:B R1:B
RR1 R0 R1 3.158k $SUB=sub! $[rhigh] w=0.5e-6 l=0.96e-6 b=0
.ends
