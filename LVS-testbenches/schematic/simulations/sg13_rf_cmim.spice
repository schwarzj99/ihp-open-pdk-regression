** sch_path: /foss/designs/ihp-open-pdk-regression/LVS-testbenches/schematic/sg13_rf_cmim.sch
.subckt sg13_rf_cmim C0 C1 CX
*.PININFO C0:B C1:B CX:B
CC1 C0 C1 CX rfcmim w=10.0e-6 l=10.0e-6 wfeed=5.0e-6
.ends
