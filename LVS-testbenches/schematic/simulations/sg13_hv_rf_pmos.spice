** sch_path: /foss/designs/ihp-open-pdk-regression/LVS-testbenches/schematic/sg13_hv_rf_pmos.sch
.subckt sg13_hv_rf_pmos D G S B lvs_model w l ng m

*.PININFO D:B S:B G:B B:B
MM1 S G D B rfpmoshv w=1.0u l=0.72u ng=1
.ends
