** sch_path: /foss/designs/ihp-open-pdk-regression/LVS-testbenches/schematic/sg13_lv_nmos_ring.sch
.subckt sg13_lv_nmos_ring D S G B
*.PININFO D:B S:B G:B B:B
MM1 D G S net1 sg13_lv_nmos w=0.15u l=0.13u ng=1
RR1 B net1 ptap1 A=2.868e-12 P=1.912e-05
.ends
