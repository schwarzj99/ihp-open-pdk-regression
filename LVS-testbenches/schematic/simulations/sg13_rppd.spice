** sch_path: /foss/designs/ihp-open-pdk-regression/LVS-testbenches/schematic/sg13_rppd.sch
.subckt sg13_rppd R0 R1
*.PININFO R0:B R1:B
RR1 R0 R1 396.9 $SUB=sub! $[rppd] w=0.5e-6 l=0.5e-6 b=0
.ends
