** sch_path: /foss/designs/ihp-open-pdk-regression/LVS-testbenches/schematic/sg13_lv_pmos_ring.sch
.subckt sg13_lv_pmos_ring D S G B
*.PININFO D:B S:B G:B B:B
MM1 D G S net1 sg13_lv_pmos w=0.15u l=0.13u ng=1
RR1 B net1 ntap1 A=3.486e-12 P=2.324e-05
.ends
