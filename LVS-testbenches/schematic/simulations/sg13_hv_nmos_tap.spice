** sch_path: /foss/designs/ihp-open-pdk-regression/LVS-testbenches/schematic/sg13_hv_nmos_tap.sch
.subckt sg13_hv_nmos_tap D S G B
*.PININFO D:B S:B G:B B:B
RR1 B net1 ptap1 A=6.084e-13 P=3.12e-06
MM1 D G S net1 sg13_hv_nmos w=0.3u l=0.45u ng=1
.ends
