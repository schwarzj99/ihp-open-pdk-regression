* PEX produced on Mon Jul  6 05:15:33 PM CEST 2026 using /foss/designs/sak/sak-pex.sh with m=3 and s=1 (extresist threshold=10000 mOhm, minres=1000 mOhm, mindelay=0 ps)
* NGSPICE file created from cmom_m1_f2.ext - technology: ihp-sg13g2

.subckt cmom_m1_f2 A B
C0 A B 0.92015f
C1 B w_n32_n304# 0.1354f
C2 A w_n32_n304# 0.20909f
.ends
