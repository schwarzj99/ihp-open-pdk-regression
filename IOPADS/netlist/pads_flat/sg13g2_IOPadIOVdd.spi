* sg13g2_IOPadIOVdd (flattened)

* Every sub-block inlined, for comparison against a flat extraction.
* Generated from sg13g2_io.spi; edit the source, not this file.

* Autogenerated file; please don't edit
* date: 2024-05-27 14:30:57.050559

************************************************************************
*
* Copyright 2024 IHP PDK Authors
*
* Licensed under the Apache License, Version 2.0 (the "License");
* you may not use this file except in compliance with the License.
* You may obtain a copy of the License at
*
*    https://www.apache.org/licenses/LICENSE-2.0
*
* Unless required by applicable law or agreed to in writing, software
* distributed under the License is distributed on an "AS IS" BASIS,
* WITHOUT WARRANTIES OR CONDITIONS OF ANY KIND, either express or implied.
* See the License for the specific language governing permissions and
* limitations under the License.
*
************************************************************************

.subckt sg13g2_IOPadIOVdd iovdd iovss vdd vss
Xnclamp.clamp_g0_r0 vss ngate iovdd vss sg13_hv_nmos l=0.6um w=4.4um
Xnclamp.clamp_g0_r1 vss ngate iovdd vss sg13_hv_nmos l=0.6um w=4.4um
Xnclamp.clamp_g0_r2 vss ngate iovdd vss sg13_hv_nmos l=0.6um w=4.4um
Xnclamp.clamp_g0_r3 vss ngate iovdd vss sg13_hv_nmos l=0.6um w=4.4um
Xnclamp.clamp_g1_r0 iovdd ngate vss vss sg13_hv_nmos l=0.6um w=4.4um
Xnclamp.clamp_g1_r1 iovdd ngate vss vss sg13_hv_nmos l=0.6um w=4.4um
Xnclamp.clamp_g1_r2 iovdd ngate vss vss sg13_hv_nmos l=0.6um w=4.4um
Xnclamp.clamp_g1_r3 iovdd ngate vss vss sg13_hv_nmos l=0.6um w=4.4um
Xnclamp.clamp_g2_r0 vss ngate iovdd vss sg13_hv_nmos l=0.6um w=4.4um
Xnclamp.clamp_g2_r1 vss ngate iovdd vss sg13_hv_nmos l=0.6um w=4.4um
Xnclamp.clamp_g2_r2 vss ngate iovdd vss sg13_hv_nmos l=0.6um w=4.4um
Xnclamp.clamp_g2_r3 vss ngate iovdd vss sg13_hv_nmos l=0.6um w=4.4um
Xnclamp.clamp_g3_r0 iovdd ngate vss vss sg13_hv_nmos l=0.6um w=4.4um
Xnclamp.clamp_g3_r1 iovdd ngate vss vss sg13_hv_nmos l=0.6um w=4.4um
Xnclamp.clamp_g3_r2 iovdd ngate vss vss sg13_hv_nmos l=0.6um w=4.4um
Xnclamp.clamp_g3_r3 iovdd ngate vss vss sg13_hv_nmos l=0.6um w=4.4um
Xnclamp.clamp_g4_r0 vss ngate iovdd vss sg13_hv_nmos l=0.6um w=4.4um
Xnclamp.clamp_g4_r1 vss ngate iovdd vss sg13_hv_nmos l=0.6um w=4.4um
Xnclamp.clamp_g4_r2 vss ngate iovdd vss sg13_hv_nmos l=0.6um w=4.4um
Xnclamp.clamp_g4_r3 vss ngate iovdd vss sg13_hv_nmos l=0.6um w=4.4um
Xnclamp.clamp_g5_r0 iovdd ngate vss vss sg13_hv_nmos l=0.6um w=4.4um
Xnclamp.clamp_g5_r1 iovdd ngate vss vss sg13_hv_nmos l=0.6um w=4.4um
Xnclamp.clamp_g5_r2 iovdd ngate vss vss sg13_hv_nmos l=0.6um w=4.4um
Xnclamp.clamp_g5_r3 iovdd ngate vss vss sg13_hv_nmos l=0.6um w=4.4um
Xnclamp.clamp_g6_r0 vss ngate iovdd vss sg13_hv_nmos l=0.6um w=4.4um
Xnclamp.clamp_g6_r1 vss ngate iovdd vss sg13_hv_nmos l=0.6um w=4.4um
Xnclamp.clamp_g6_r2 vss ngate iovdd vss sg13_hv_nmos l=0.6um w=4.4um
Xnclamp.clamp_g6_r3 vss ngate iovdd vss sg13_hv_nmos l=0.6um w=4.4um
Xnclamp.clamp_g7_r0 iovdd ngate vss vss sg13_hv_nmos l=0.6um w=4.4um
Xnclamp.clamp_g7_r1 iovdd ngate vss vss sg13_hv_nmos l=0.6um w=4.4um
Xnclamp.clamp_g7_r2 iovdd ngate vss vss sg13_hv_nmos l=0.6um w=4.4um
Xnclamp.clamp_g7_r3 iovdd ngate vss vss sg13_hv_nmos l=0.6um w=4.4um
Xnclamp.clamp_g8_r0 vss ngate iovdd vss sg13_hv_nmos l=0.6um w=4.4um
Xnclamp.clamp_g8_r1 vss ngate iovdd vss sg13_hv_nmos l=0.6um w=4.4um
Xnclamp.clamp_g8_r2 vss ngate iovdd vss sg13_hv_nmos l=0.6um w=4.4um
Xnclamp.clamp_g8_r3 vss ngate iovdd vss sg13_hv_nmos l=0.6um w=4.4um
Xnclamp.clamp_g9_r0 iovdd ngate vss vss sg13_hv_nmos l=0.6um w=4.4um
Xnclamp.clamp_g9_r1 iovdd ngate vss vss sg13_hv_nmos l=0.6um w=4.4um
Xnclamp.clamp_g9_r2 iovdd ngate vss vss sg13_hv_nmos l=0.6um w=4.4um
Xnclamp.clamp_g9_r3 iovdd ngate vss vss sg13_hv_nmos l=0.6um w=4.4um
Xnclamp.clamp_g10_r0 vss ngate iovdd vss sg13_hv_nmos l=0.6um w=4.4um
Xnclamp.clamp_g10_r1 vss ngate iovdd vss sg13_hv_nmos l=0.6um w=4.4um
Xnclamp.clamp_g10_r2 vss ngate iovdd vss sg13_hv_nmos l=0.6um w=4.4um
Xnclamp.clamp_g10_r3 vss ngate iovdd vss sg13_hv_nmos l=0.6um w=4.4um
Xnclamp.clamp_g11_r0 iovdd ngate vss vss sg13_hv_nmos l=0.6um w=4.4um
Xnclamp.clamp_g11_r1 iovdd ngate vss vss sg13_hv_nmos l=0.6um w=4.4um
Xnclamp.clamp_g11_r2 iovdd ngate vss vss sg13_hv_nmos l=0.6um w=4.4um
Xnclamp.clamp_g11_r3 iovdd ngate vss vss sg13_hv_nmos l=0.6um w=4.4um
Xnclamp.clamp_g12_r0 vss ngate iovdd vss sg13_hv_nmos l=0.6um w=4.4um
Xnclamp.clamp_g12_r1 vss ngate iovdd vss sg13_hv_nmos l=0.6um w=4.4um
Xnclamp.clamp_g12_r2 vss ngate iovdd vss sg13_hv_nmos l=0.6um w=4.4um
Xnclamp.clamp_g12_r3 vss ngate iovdd vss sg13_hv_nmos l=0.6um w=4.4um
Xnclamp.clamp_g13_r0 iovdd ngate vss vss sg13_hv_nmos l=0.6um w=4.4um
Xnclamp.clamp_g13_r1 iovdd ngate vss vss sg13_hv_nmos l=0.6um w=4.4um
Xnclamp.clamp_g13_r2 iovdd ngate vss vss sg13_hv_nmos l=0.6um w=4.4um
Xnclamp.clamp_g13_r3 iovdd ngate vss vss sg13_hv_nmos l=0.6um w=4.4um
Xnclamp.clamp_g14_r0 vss ngate iovdd vss sg13_hv_nmos l=0.6um w=4.4um
Xnclamp.clamp_g14_r1 vss ngate iovdd vss sg13_hv_nmos l=0.6um w=4.4um
Xnclamp.clamp_g14_r2 vss ngate iovdd vss sg13_hv_nmos l=0.6um w=4.4um
Xnclamp.clamp_g14_r3 vss ngate iovdd vss sg13_hv_nmos l=0.6um w=4.4um
Xnclamp.clamp_g15_r0 iovdd ngate vss vss sg13_hv_nmos l=0.6um w=4.4um
Xnclamp.clamp_g15_r1 iovdd ngate vss vss sg13_hv_nmos l=0.6um w=4.4um
Xnclamp.clamp_g15_r2 iovdd ngate vss vss sg13_hv_nmos l=0.6um w=4.4um
Xnclamp.clamp_g15_r3 iovdd ngate vss vss sg13_hv_nmos l=0.6um w=4.4um
Xnclamp.clamp_g16_r0 vss ngate iovdd vss sg13_hv_nmos l=0.6um w=4.4um
Xnclamp.clamp_g16_r1 vss ngate iovdd vss sg13_hv_nmos l=0.6um w=4.4um
Xnclamp.clamp_g16_r2 vss ngate iovdd vss sg13_hv_nmos l=0.6um w=4.4um
Xnclamp.clamp_g16_r3 vss ngate iovdd vss sg13_hv_nmos l=0.6um w=4.4um
Xnclamp.clamp_g17_r0 iovdd ngate vss vss sg13_hv_nmos l=0.6um w=4.4um
Xnclamp.clamp_g17_r1 iovdd ngate vss vss sg13_hv_nmos l=0.6um w=4.4um
Xnclamp.clamp_g17_r2 iovdd ngate vss vss sg13_hv_nmos l=0.6um w=4.4um
Xnclamp.clamp_g17_r3 iovdd ngate vss vss sg13_hv_nmos l=0.6um w=4.4um
Xnclamp.clamp_g18_r0 vss ngate iovdd vss sg13_hv_nmos l=0.6um w=4.4um
Xnclamp.clamp_g18_r1 vss ngate iovdd vss sg13_hv_nmos l=0.6um w=4.4um
Xnclamp.clamp_g18_r2 vss ngate iovdd vss sg13_hv_nmos l=0.6um w=4.4um
Xnclamp.clamp_g18_r3 vss ngate iovdd vss sg13_hv_nmos l=0.6um w=4.4um
Xnclamp.clamp_g19_r0 iovdd ngate vss vss sg13_hv_nmos l=0.6um w=4.4um
Xnclamp.clamp_g19_r1 iovdd ngate vss vss sg13_hv_nmos l=0.6um w=4.4um
Xnclamp.clamp_g19_r2 iovdd ngate vss vss sg13_hv_nmos l=0.6um w=4.4um
Xnclamp.clamp_g19_r3 iovdd ngate vss vss sg13_hv_nmos l=0.6um w=4.4um
Xnclamp.clamp_g20_r0 vss ngate iovdd vss sg13_hv_nmos l=0.6um w=4.4um
Xnclamp.clamp_g20_r1 vss ngate iovdd vss sg13_hv_nmos l=0.6um w=4.4um
Xnclamp.clamp_g20_r2 vss ngate iovdd vss sg13_hv_nmos l=0.6um w=4.4um
Xnclamp.clamp_g20_r3 vss ngate iovdd vss sg13_hv_nmos l=0.6um w=4.4um
Xnclamp.clamp_g21_r0 iovdd ngate vss vss sg13_hv_nmos l=0.6um w=4.4um
Xnclamp.clamp_g21_r1 iovdd ngate vss vss sg13_hv_nmos l=0.6um w=4.4um
Xnclamp.clamp_g21_r2 iovdd ngate vss vss sg13_hv_nmos l=0.6um w=4.4um
Xnclamp.clamp_g21_r3 iovdd ngate vss vss sg13_hv_nmos l=0.6um w=4.4um
Xnclamp.clamp_g22_r0 vss ngate iovdd vss sg13_hv_nmos l=0.6um w=4.4um
Xnclamp.clamp_g22_r1 vss ngate iovdd vss sg13_hv_nmos l=0.6um w=4.4um
Xnclamp.clamp_g22_r2 vss ngate iovdd vss sg13_hv_nmos l=0.6um w=4.4um
Xnclamp.clamp_g22_r3 vss ngate iovdd vss sg13_hv_nmos l=0.6um w=4.4um
Xnclamp.clamp_g23_r0 iovdd ngate vss vss sg13_hv_nmos l=0.6um w=4.4um
Xnclamp.clamp_g23_r1 iovdd ngate vss vss sg13_hv_nmos l=0.6um w=4.4um
Xnclamp.clamp_g23_r2 iovdd ngate vss vss sg13_hv_nmos l=0.6um w=4.4um
Xnclamp.clamp_g23_r3 iovdd ngate vss vss sg13_hv_nmos l=0.6um w=4.4um
Xnclamp.clamp_g24_r0 vss ngate iovdd vss sg13_hv_nmos l=0.6um w=4.4um
Xnclamp.clamp_g24_r1 vss ngate iovdd vss sg13_hv_nmos l=0.6um w=4.4um
Xnclamp.clamp_g24_r2 vss ngate iovdd vss sg13_hv_nmos l=0.6um w=4.4um
Xnclamp.clamp_g24_r3 vss ngate iovdd vss sg13_hv_nmos l=0.6um w=4.4um
Xnclamp.clamp_g25_r0 iovdd ngate vss vss sg13_hv_nmos l=0.6um w=4.4um
Xnclamp.clamp_g25_r1 iovdd ngate vss vss sg13_hv_nmos l=0.6um w=4.4um
Xnclamp.clamp_g25_r2 iovdd ngate vss vss sg13_hv_nmos l=0.6um w=4.4um
Xnclamp.clamp_g25_r3 iovdd ngate vss vss sg13_hv_nmos l=0.6um w=4.4um
Xnclamp.clamp_g26_r0 vss ngate iovdd vss sg13_hv_nmos l=0.6um w=4.4um
Xnclamp.clamp_g26_r1 vss ngate iovdd vss sg13_hv_nmos l=0.6um w=4.4um
Xnclamp.clamp_g26_r2 vss ngate iovdd vss sg13_hv_nmos l=0.6um w=4.4um
Xnclamp.clamp_g26_r3 vss ngate iovdd vss sg13_hv_nmos l=0.6um w=4.4um
Xnclamp.clamp_g27_r0 iovdd ngate vss vss sg13_hv_nmos l=0.6um w=4.4um
Xnclamp.clamp_g27_r1 iovdd ngate vss vss sg13_hv_nmos l=0.6um w=4.4um
Xnclamp.clamp_g27_r2 iovdd ngate vss vss sg13_hv_nmos l=0.6um w=4.4um
Xnclamp.clamp_g27_r3 iovdd ngate vss vss sg13_hv_nmos l=0.6um w=4.4um
Xnclamp.clamp_g28_r0 vss ngate iovdd vss sg13_hv_nmos l=0.6um w=4.4um
Xnclamp.clamp_g28_r1 vss ngate iovdd vss sg13_hv_nmos l=0.6um w=4.4um
Xnclamp.clamp_g28_r2 vss ngate iovdd vss sg13_hv_nmos l=0.6um w=4.4um
Xnclamp.clamp_g28_r3 vss ngate iovdd vss sg13_hv_nmos l=0.6um w=4.4um
Xnclamp.clamp_g29_r0 iovdd ngate vss vss sg13_hv_nmos l=0.6um w=4.4um
Xnclamp.clamp_g29_r1 iovdd ngate vss vss sg13_hv_nmos l=0.6um w=4.4um
Xnclamp.clamp_g29_r2 iovdd ngate vss vss sg13_hv_nmos l=0.6um w=4.4um
Xnclamp.clamp_g29_r3 iovdd ngate vss vss sg13_hv_nmos l=0.6um w=4.4um
Xnclamp.clamp_g30_r0 vss ngate iovdd vss sg13_hv_nmos l=0.6um w=4.4um
Xnclamp.clamp_g30_r1 vss ngate iovdd vss sg13_hv_nmos l=0.6um w=4.4um
Xnclamp.clamp_g30_r2 vss ngate iovdd vss sg13_hv_nmos l=0.6um w=4.4um
Xnclamp.clamp_g30_r3 vss ngate iovdd vss sg13_hv_nmos l=0.6um w=4.4um
Xnclamp.clamp_g31_r0 iovdd ngate vss vss sg13_hv_nmos l=0.6um w=4.4um
Xnclamp.clamp_g31_r1 iovdd ngate vss vss sg13_hv_nmos l=0.6um w=4.4um
Xnclamp.clamp_g31_r2 iovdd ngate vss vss sg13_hv_nmos l=0.6um w=4.4um
Xnclamp.clamp_g31_r3 iovdd ngate vss vss sg13_hv_nmos l=0.6um w=4.4um
Xnclamp.clamp_g32_r0 vss ngate iovdd vss sg13_hv_nmos l=0.6um w=4.4um
Xnclamp.clamp_g32_r1 vss ngate iovdd vss sg13_hv_nmos l=0.6um w=4.4um
Xnclamp.clamp_g32_r2 vss ngate iovdd vss sg13_hv_nmos l=0.6um w=4.4um
Xnclamp.clamp_g32_r3 vss ngate iovdd vss sg13_hv_nmos l=0.6um w=4.4um
Xnclamp.clamp_g33_r0 iovdd ngate vss vss sg13_hv_nmos l=0.6um w=4.4um
Xnclamp.clamp_g33_r1 iovdd ngate vss vss sg13_hv_nmos l=0.6um w=4.4um
Xnclamp.clamp_g33_r2 iovdd ngate vss vss sg13_hv_nmos l=0.6um w=4.4um
Xnclamp.clamp_g33_r3 iovdd ngate vss vss sg13_hv_nmos l=0.6um w=4.4um
Xnclamp.clamp_g34_r0 vss ngate iovdd vss sg13_hv_nmos l=0.6um w=4.4um
Xnclamp.clamp_g34_r1 vss ngate iovdd vss sg13_hv_nmos l=0.6um w=4.4um
Xnclamp.clamp_g34_r2 vss ngate iovdd vss sg13_hv_nmos l=0.6um w=4.4um
Xnclamp.clamp_g34_r3 vss ngate iovdd vss sg13_hv_nmos l=0.6um w=4.4um
Xnclamp.clamp_g35_r0 iovdd ngate vss vss sg13_hv_nmos l=0.6um w=4.4um
Xnclamp.clamp_g35_r1 iovdd ngate vss vss sg13_hv_nmos l=0.6um w=4.4um
Xnclamp.clamp_g35_r2 iovdd ngate vss vss sg13_hv_nmos l=0.6um w=4.4um
Xnclamp.clamp_g35_r3 iovdd ngate vss vss sg13_hv_nmos l=0.6um w=4.4um
Xnclamp.clamp_g36_r0 vss ngate iovdd vss sg13_hv_nmos l=0.6um w=4.4um
Xnclamp.clamp_g36_r1 vss ngate iovdd vss sg13_hv_nmos l=0.6um w=4.4um
Xnclamp.clamp_g36_r2 vss ngate iovdd vss sg13_hv_nmos l=0.6um w=4.4um
Xnclamp.clamp_g36_r3 vss ngate iovdd vss sg13_hv_nmos l=0.6um w=4.4um
Xnclamp.clamp_g37_r0 iovdd ngate vss vss sg13_hv_nmos l=0.6um w=4.4um
Xnclamp.clamp_g37_r1 iovdd ngate vss vss sg13_hv_nmos l=0.6um w=4.4um
Xnclamp.clamp_g37_r2 iovdd ngate vss vss sg13_hv_nmos l=0.6um w=4.4um
Xnclamp.clamp_g37_r3 iovdd ngate vss vss sg13_hv_nmos l=0.6um w=4.4um
Xnclamp.clamp_g38_r0 vss ngate iovdd vss sg13_hv_nmos l=0.6um w=4.4um
Xnclamp.clamp_g38_r1 vss ngate iovdd vss sg13_hv_nmos l=0.6um w=4.4um
Xnclamp.clamp_g38_r2 vss ngate iovdd vss sg13_hv_nmos l=0.6um w=4.4um
Xnclamp.clamp_g38_r3 vss ngate iovdd vss sg13_hv_nmos l=0.6um w=4.4um
Xnclamp.clamp_g39_r0 iovdd ngate vss vss sg13_hv_nmos l=0.6um w=4.4um
Xnclamp.clamp_g39_r1 iovdd ngate vss vss sg13_hv_nmos l=0.6um w=4.4um
Xnclamp.clamp_g39_r2 iovdd ngate vss vss sg13_hv_nmos l=0.6um w=4.4um
Xnclamp.clamp_g39_r3 iovdd ngate vss vss sg13_hv_nmos l=0.6um w=4.4um
Xnclamp.clamp_g40_r0 vss ngate iovdd vss sg13_hv_nmos l=0.6um w=4.4um
Xnclamp.clamp_g40_r1 vss ngate iovdd vss sg13_hv_nmos l=0.6um w=4.4um
Xnclamp.clamp_g40_r2 vss ngate iovdd vss sg13_hv_nmos l=0.6um w=4.4um
Xnclamp.clamp_g40_r3 vss ngate iovdd vss sg13_hv_nmos l=0.6um w=4.4um
Xnclamp.clamp_g41_r0 iovdd ngate vss vss sg13_hv_nmos l=0.6um w=4.4um
Xnclamp.clamp_g41_r1 iovdd ngate vss vss sg13_hv_nmos l=0.6um w=4.4um
Xnclamp.clamp_g41_r2 iovdd ngate vss vss sg13_hv_nmos l=0.6um w=4.4um
Xnclamp.clamp_g41_r3 iovdd ngate vss vss sg13_hv_nmos l=0.6um w=4.4um
Xnclamp.clamp_g42_r0 vss ngate iovdd vss sg13_hv_nmos l=0.6um w=4.4um
Xnclamp.clamp_g42_r1 vss ngate iovdd vss sg13_hv_nmos l=0.6um w=4.4um
Xnclamp.clamp_g42_r2 vss ngate iovdd vss sg13_hv_nmos l=0.6um w=4.4um
Xnclamp.clamp_g42_r3 vss ngate iovdd vss sg13_hv_nmos l=0.6um w=4.4um
Xnclamp.DGATE vss ngate dantenna l=0.48um w=0.48um
Xrcres.res_fing[0] iovdd rcres.conn_0_1 vss rppd l=20.0um w=1.0um
Xrcres.res_fing[1] rcres.conn_0_1 rcres.conn_1_2 vss rppd l=20.0um w=1.0um
Xrcres.res_fing[2] rcres.conn_1_2 rcres.conn_2_3 vss rppd l=20.0um w=1.0um
Xrcres.res_fing[3] rcres.conn_2_3 rcres.conn_3_4 vss rppd l=20.0um w=1.0um
Xrcres.res_fing[4] rcres.conn_3_4 rcres.conn_4_5 vss rppd l=20.0um w=1.0um
Xrcres.res_fing[5] rcres.conn_4_5 rcres.conn_5_6 vss rppd l=20.0um w=1.0um
Xrcres.res_fing[6] rcres.conn_5_6 rcres.conn_6_7 vss rppd l=20.0um w=1.0um
Xrcres.res_fing[7] rcres.conn_6_7 rcres.conn_7_8 vss rppd l=20.0um w=1.0um
Xrcres.res_fing[8] rcres.conn_7_8 rcres.conn_8_9 vss rppd l=20.0um w=1.0um
Xrcres.res_fing[9] rcres.conn_8_9 rcres.conn_9_10 vss rppd l=20.0um w=1.0um
Xrcres.res_fing[10] rcres.conn_9_10 rcres.conn_10_11 vss rppd l=20.0um w=1.0um
Xrcres.res_fing[11] rcres.conn_10_11 rcres.conn_11_12 vss rppd l=20.0um w=1.0um
Xrcres.res_fing[12] rcres.conn_11_12 rcres.conn_12_13 vss rppd l=20.0um w=1.0um
Xrcres.res_fing[13] rcres.conn_12_13 rcres.conn_13_14 vss rppd l=20.0um w=1.0um
Xrcres.res_fing[14] rcres.conn_13_14 rcres.conn_14_15 vss rppd l=20.0um w=1.0um
Xrcres.res_fing[15] rcres.conn_14_15 rcres.conn_15_16 vss rppd l=20.0um w=1.0um
Xrcres.res_fing[16] rcres.conn_15_16 rcres.conn_16_17 vss rppd l=20.0um w=1.0um
Xrcres.res_fing[17] rcres.conn_16_17 rcres.conn_17_18 vss rppd l=20.0um w=1.0um
Xrcres.res_fing[18] rcres.conn_17_18 rcres.conn_18_19 vss rppd l=20.0um w=1.0um
Xrcres.res_fing[19] rcres.conn_18_19 rcres.conn_19_20 vss rppd l=20.0um w=1.0um
Xrcres.res_fing[20] rcres.conn_19_20 rcres.conn_20_21 vss rppd l=20.0um w=1.0um
Xrcres.res_fing[21] rcres.conn_20_21 rcres.conn_21_22 vss rppd l=20.0um w=1.0um
Xrcres.res_fing[22] rcres.conn_21_22 rcres.conn_22_23 vss rppd l=20.0um w=1.0um
Xrcres.res_fing[23] rcres.conn_22_23 rcres.conn_23_24 vss rppd l=20.0um w=1.0um
Xrcres.res_fing[24] rcres.conn_23_24 rcres.conn_24_25 vss rppd l=20.0um w=1.0um
Xrcres.res_fing[25] rcres.conn_24_25 res_cap vss rppd l=20.0um w=1.0um
Xrcinv.capmos0_r0 vss res_cap vss vss sg13_hv_nmos l=9.5um w=9.0um
Xrcinv.capmos1_r0 vss res_cap vss vss sg13_hv_nmos l=9.5um w=9.0um
Xrcinv.capmos2_r0 vss res_cap vss vss sg13_hv_nmos l=9.5um w=9.0um
Xrcinv.capmos3_r0 vss res_cap vss vss sg13_hv_nmos l=9.5um w=9.0um
Xrcinv.capmos4_r0 vss res_cap vss vss sg13_hv_nmos l=9.5um w=9.0um
Xrcinv.capmos5_r0 vss res_cap vss vss sg13_hv_nmos l=9.5um w=9.0um
Xrcinv.capmos6_r0 vss res_cap vss vss sg13_hv_nmos l=9.5um w=9.0um
Xrcinv.nmos0_r0 vss res_cap ngate vss sg13_hv_nmos l=0.5um w=9.0um
Xrcinv.nmos1_r0 ngate res_cap vss vss sg13_hv_nmos l=0.5um w=9.0um
Xrcinv.nmos2_r0 vss res_cap ngate vss sg13_hv_nmos l=0.5um w=9.0um
Xrcinv.nmos3_r0 ngate res_cap vss vss sg13_hv_nmos l=0.5um w=9.0um
Xrcinv.nmos4_r0 vss res_cap ngate vss sg13_hv_nmos l=0.5um w=9.0um
Xrcinv.nmos5_r0 ngate res_cap vss vss sg13_hv_nmos l=0.5um w=9.0um
Xrcinv.capmos0_r1 vss res_cap vss vss sg13_hv_nmos l=9.5um w=9.0um
Xrcinv.capmos1_r1 vss res_cap vss vss sg13_hv_nmos l=9.5um w=9.0um
Xrcinv.capmos2_r1 vss res_cap vss vss sg13_hv_nmos l=9.5um w=9.0um
Xrcinv.capmos3_r1 vss res_cap vss vss sg13_hv_nmos l=9.5um w=9.0um
Xrcinv.capmos4_r1 vss res_cap vss vss sg13_hv_nmos l=9.5um w=9.0um
Xrcinv.capmos5_r1 vss res_cap vss vss sg13_hv_nmos l=9.5um w=9.0um
Xrcinv.capmos6_r1 vss res_cap vss vss sg13_hv_nmos l=9.5um w=9.0um
Xrcinv.nmos0_r1 vss res_cap ngate vss sg13_hv_nmos l=0.5um w=9.0um
Xrcinv.nmos1_r1 ngate res_cap vss vss sg13_hv_nmos l=0.5um w=9.0um
Xrcinv.nmos2_r1 vss res_cap ngate vss sg13_hv_nmos l=0.5um w=9.0um
Xrcinv.nmos3_r1 ngate res_cap vss vss sg13_hv_nmos l=0.5um w=9.0um
Xrcinv.nmos4_r1 vss res_cap ngate vss sg13_hv_nmos l=0.5um w=9.0um
Xrcinv.nmos5_r1 ngate res_cap vss vss sg13_hv_nmos l=0.5um w=9.0um
Xrcinv.pmos0_r0 iovdd res_cap ngate iovdd sg13_hv_pmos l=0.5um w=7.0um
Xrcinv.pmos1_r0 ngate res_cap iovdd iovdd sg13_hv_pmos l=0.5um w=7.0um
Xrcinv.pmos2_r0 iovdd res_cap ngate iovdd sg13_hv_pmos l=0.5um w=7.0um
Xrcinv.pmos3_r0 ngate res_cap iovdd iovdd sg13_hv_pmos l=0.5um w=7.0um
Xrcinv.pmos4_r0 iovdd res_cap ngate iovdd sg13_hv_pmos l=0.5um w=7.0um
Xrcinv.pmos5_r0 ngate res_cap iovdd iovdd sg13_hv_pmos l=0.5um w=7.0um
Xrcinv.pmos6_r0 iovdd res_cap ngate iovdd sg13_hv_pmos l=0.5um w=7.0um
Xrcinv.pmos7_r0 ngate res_cap iovdd iovdd sg13_hv_pmos l=0.5um w=7.0um
Xrcinv.pmos8_r0 iovdd res_cap ngate iovdd sg13_hv_pmos l=0.5um w=7.0um
Xrcinv.pmos9_r0 ngate res_cap iovdd iovdd sg13_hv_pmos l=0.5um w=7.0um
Xrcinv.pmos10_r0 iovdd res_cap ngate iovdd sg13_hv_pmos l=0.5um w=7.0um
Xrcinv.pmos11_r0 ngate res_cap iovdd iovdd sg13_hv_pmos l=0.5um w=7.0um
Xrcinv.pmos12_r0 iovdd res_cap ngate iovdd sg13_hv_pmos l=0.5um w=7.0um
Xrcinv.pmos13_r0 ngate res_cap iovdd iovdd sg13_hv_pmos l=0.5um w=7.0um
Xrcinv.pmos14_r0 iovdd res_cap ngate iovdd sg13_hv_pmos l=0.5um w=7.0um
Xrcinv.pmos15_r0 ngate res_cap iovdd iovdd sg13_hv_pmos l=0.5um w=7.0um
Xrcinv.pmos16_r0 iovdd res_cap ngate iovdd sg13_hv_pmos l=0.5um w=7.0um
Xrcinv.pmos17_r0 ngate res_cap iovdd iovdd sg13_hv_pmos l=0.5um w=7.0um
Xrcinv.pmos18_r0 iovdd res_cap ngate iovdd sg13_hv_pmos l=0.5um w=7.0um
Xrcinv.pmos19_r0 ngate res_cap iovdd iovdd sg13_hv_pmos l=0.5um w=7.0um
Xrcinv.pmos20_r0 iovdd res_cap ngate iovdd sg13_hv_pmos l=0.5um w=7.0um
Xrcinv.pmos21_r0 ngate res_cap iovdd iovdd sg13_hv_pmos l=0.5um w=7.0um
Xrcinv.pmos22_r0 iovdd res_cap ngate iovdd sg13_hv_pmos l=0.5um w=7.0um
Xrcinv.pmos23_r0 ngate res_cap iovdd iovdd sg13_hv_pmos l=0.5um w=7.0um
Xrcinv.pmos24_r0 iovdd res_cap ngate iovdd sg13_hv_pmos l=0.5um w=7.0um
Xrcinv.pmos25_r0 ngate res_cap iovdd iovdd sg13_hv_pmos l=0.5um w=7.0um
Xrcinv.pmos26_r0 iovdd res_cap ngate iovdd sg13_hv_pmos l=0.5um w=7.0um
Xrcinv.pmos27_r0 ngate res_cap iovdd iovdd sg13_hv_pmos l=0.5um w=7.0um
Xrcinv.pmos28_r0 iovdd res_cap ngate iovdd sg13_hv_pmos l=0.5um w=7.0um
Xrcinv.pmos29_r0 ngate res_cap iovdd iovdd sg13_hv_pmos l=0.5um w=7.0um
Xrcinv.pmos30_r0 iovdd res_cap ngate iovdd sg13_hv_pmos l=0.5um w=7.0um
Xrcinv.pmos31_r0 ngate res_cap iovdd iovdd sg13_hv_pmos l=0.5um w=7.0um
Xrcinv.pmos32_r0 iovdd res_cap ngate iovdd sg13_hv_pmos l=0.5um w=7.0um
Xrcinv.pmos33_r0 ngate res_cap iovdd iovdd sg13_hv_pmos l=0.5um w=7.0um
Xrcinv.pmos34_r0 iovdd res_cap ngate iovdd sg13_hv_pmos l=0.5um w=7.0um
Xrcinv.pmos35_r0 ngate res_cap iovdd iovdd sg13_hv_pmos l=0.5um w=7.0um
Xrcinv.pmos36_r0 iovdd res_cap ngate iovdd sg13_hv_pmos l=0.5um w=7.0um
Xrcinv.pmos37_r0 ngate res_cap iovdd iovdd sg13_hv_pmos l=0.5um w=7.0um
Xrcinv.pmos38_r0 iovdd res_cap ngate iovdd sg13_hv_pmos l=0.5um w=7.0um
Xrcinv.pmos39_r0 ngate res_cap iovdd iovdd sg13_hv_pmos l=0.5um w=7.0um
Xrcinv.pmos40_r0 iovdd res_cap ngate iovdd sg13_hv_pmos l=0.5um w=7.0um
Xrcinv.pmos41_r0 ngate res_cap iovdd iovdd sg13_hv_pmos l=0.5um w=7.0um
Xrcinv.pmos42_r0 iovdd res_cap ngate iovdd sg13_hv_pmos l=0.5um w=7.0um
Xrcinv.pmos43_r0 ngate res_cap iovdd iovdd sg13_hv_pmos l=0.5um w=7.0um
Xrcinv.pmos44_r0 iovdd res_cap ngate iovdd sg13_hv_pmos l=0.5um w=7.0um
Xrcinv.pmos45_r0 ngate res_cap iovdd iovdd sg13_hv_pmos l=0.5um w=7.0um
Xrcinv.pmos46_r0 iovdd res_cap ngate iovdd sg13_hv_pmos l=0.5um w=7.0um
Xrcinv.pmos47_r0 ngate res_cap iovdd iovdd sg13_hv_pmos l=0.5um w=7.0um
Xrcinv.pmos48_r0 iovdd res_cap ngate iovdd sg13_hv_pmos l=0.5um w=7.0um
Xrcinv.pmos49_r0 ngate res_cap iovdd iovdd sg13_hv_pmos l=0.5um w=7.0um
.ends sg13g2_IOPadIOVdd
