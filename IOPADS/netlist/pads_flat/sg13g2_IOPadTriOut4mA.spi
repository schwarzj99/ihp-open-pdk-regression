* sg13g2_IOPadTriOut4mA (flattened)

* Every sub-block inlined, for comparison against a flat extraction.
* Generated from sg13g2_io.spi; edit the source, not this file.

* Autogenerated file; please don't edit
* date: 2024-05-27 14:30:57.050559

************************************************************************
*
* Copyright 2024 IHP PDK Authors
*
* Licensed under the Apache License, Version 2.0 (the "License");
* you may not use this file except in compliance with the License.
* You may obtain a copy of the License at
*
*    https://www.apache.org/licenses/LICENSE-2.0
*
* Unless required by applicable law or agreed to in writing, software
* distributed under the License is distributed on an "AS IS" BASIS,
* WITHOUT WARRANTIES OR CONDITIONS OF ANY KIND, either express or implied.
* See the License for the specific language governing permissions and
* limitations under the License.
*
************************************************************************

.subckt sg13g2_IOPadTriOut4mA vss vdd iovss iovdd c2p c2p_en pad
Xnclamp.clamp_g0 iovss ngate pad iovss sg13_hv_nmos l=0.6um w=4.4um
Xnclamp.clamp_g1 pad ngate iovss iovss sg13_hv_nmos l=0.6um w=4.4um
Xnclamp.DGATE iovss ngate dantenna l=0.64um w=0.48um
Xpclamp.clamp_g0_r0 iovdd pgate pad iovdd sg13_hv_pmos l=0.6um w=6.66um
Xpclamp.clamp_g0_r1 iovdd pgate pad iovdd sg13_hv_pmos l=0.6um w=6.66um
Xpclamp.clamp_g1_r0 pad pgate iovdd iovdd sg13_hv_pmos l=0.6um w=6.66um
Xpclamp.clamp_g1_r1 pad pgate iovdd iovdd sg13_hv_pmos l=0.6um w=6.66um
Xpclamp.DGATE pgate iovdd dpantenna l=0.64um w=0.48um
Xdcndiode.dcdiode[0] iovss pad dantenna l=1.26um w=27.78um
Xdcndiode.dcdiode[1] iovss pad dantenna l=1.26um w=27.78um
Xdcpdiode.dcdiode[0] pad iovdd dpantenna l=1.26um w=27.78um
Xdcpdiode.dcdiode[1] pad iovdd dpantenna l=1.26um w=27.78um
Xgatedec.en_inv.nmos vss c2p_en gatedec.en_n vss sg13_lv_nmos l=0.13um w=3.93um
Xgatedec.en_inv.pmos vdd c2p_en gatedec.en_n vdd sg13_lv_pmos l=0.13um w=4.41um
Xgatedec.ngate_nor.i0_nmos vss c2p gatedec.ngate_core vss sg13_lv_nmos l=0.13um w=3.93um
Xgatedec.ngate_nor.i0_pmos vdd c2p gatedec.ngate_nor._net0 vdd sg13_lv_pmos l=0.13um w=4.41um
Xgatedec.ngate_nor.i1_nmos gatedec.ngate_core gatedec.en_n vss vss sg13_lv_nmos l=0.13um w=3.93um
Xgatedec.ngate_nor.i1_pmos gatedec.ngate_nor._net0 gatedec.en_n gatedec.ngate_core vdd sg13_lv_pmos l=0.13um w=4.41um
Xgatedec.ngate_levelup.n_i_inv gatedec.ngate_levelup.i_n gatedec.ngate_core vss vss sg13_lv_nmos l=0.13um w=2.75um
Xgatedec.ngate_levelup.p_i_inv gatedec.ngate_levelup.i_n gatedec.ngate_core vdd vdd sg13_lv_pmos l=0.13um w=4.75um
Xgatedec.ngate_levelup.n_lvld_n vss gatedec.ngate_core gatedec.ngate_levelup.lvld_n vss sg13_hv_nmos l=0.45um w=1.9um
Xgatedec.ngate_levelup.n_lvld gatedec.ngate_levelup.lvld gatedec.ngate_levelup.i_n vss vss sg13_hv_nmos l=0.45um w=1.9um
Xgatedec.ngate_levelup.p_lvld_n iovdd gatedec.ngate_levelup.lvld gatedec.ngate_levelup.lvld_n iovdd sg13_hv_pmos l=0.45um w=0.3um
Xgatedec.ngate_levelup.p_lvld gatedec.ngate_levelup.lvld gatedec.ngate_levelup.lvld_n iovdd iovdd sg13_hv_pmos l=0.45um w=0.3um
Xgatedec.ngate_levelup.n_lvld_n_inv vss gatedec.ngate_levelup.lvld_n ngate vss sg13_hv_nmos l=0.45um w=1.9um
Xgatedec.ngate_levelup.p_lvld_n_inv iovdd gatedec.ngate_levelup.lvld_n ngate iovdd sg13_hv_pmos l=0.45um w=3.9um
Xgatedec.pgate_nand.i0_nmos vss c2p gatedec.pgate_nand._net0 vss sg13_lv_nmos l=0.13um w=3.93um
Xgatedec.pgate_nand.i0_pmos vdd c2p gatedec.pgate_core vdd sg13_lv_pmos l=0.13um w=4.41um
Xgatedec.pgate_nand.i1_nmos gatedec.pgate_nand._net0 c2p_en gatedec.pgate_core vss sg13_lv_nmos l=0.13um w=3.93um
Xgatedec.pgate_nand.i1_pmos gatedec.pgate_core c2p_en vdd vdd sg13_lv_pmos l=0.13um w=4.41um
Xgatedec.pgate_levelup.n_i_inv gatedec.pgate_levelup.i_n gatedec.pgate_core vss vss sg13_lv_nmos l=0.13um w=2.75um
Xgatedec.pgate_levelup.p_i_inv gatedec.pgate_levelup.i_n gatedec.pgate_core vdd vdd sg13_lv_pmos l=0.13um w=4.75um
Xgatedec.pgate_levelup.n_lvld_n vss gatedec.pgate_core gatedec.pgate_levelup.lvld_n vss sg13_hv_nmos l=0.45um w=1.9um
Xgatedec.pgate_levelup.n_lvld gatedec.pgate_levelup.lvld gatedec.pgate_levelup.i_n vss vss sg13_hv_nmos l=0.45um w=1.9um
Xgatedec.pgate_levelup.p_lvld_n iovdd gatedec.pgate_levelup.lvld gatedec.pgate_levelup.lvld_n iovdd sg13_hv_pmos l=0.45um w=0.3um
Xgatedec.pgate_levelup.p_lvld gatedec.pgate_levelup.lvld gatedec.pgate_levelup.lvld_n iovdd iovdd sg13_hv_pmos l=0.45um w=0.3um
Xgatedec.pgate_levelup.n_lvld_n_inv vss gatedec.pgate_levelup.lvld_n pgate vss sg13_hv_nmos l=0.45um w=1.9um
Xgatedec.pgate_levelup.p_lvld_n_inv iovdd gatedec.pgate_levelup.lvld_n pgate iovdd sg13_hv_pmos l=0.45um w=3.9um
.ends sg13g2_IOPadTriOut4mA
