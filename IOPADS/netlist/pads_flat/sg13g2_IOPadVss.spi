* sg13g2_IOPadVss (flattened)

* Every sub-block inlined, for comparison against a flat extraction.
* Generated from sg13g2_io.spi; edit the source, not this file.

* Autogenerated file; please don't edit
* date: 2024-05-27 14:30:57.050559

************************************************************************
*
* Copyright 2024 IHP PDK Authors
*
* Licensed under the Apache License, Version 2.0 (the "License");
* you may not use this file except in compliance with the License.
* You may obtain a copy of the License at
*
*    https://www.apache.org/licenses/LICENSE-2.0
*
* Unless required by applicable law or agreed to in writing, software
* distributed under the License is distributed on an "AS IS" BASIS,
* WITHOUT WARRANTIES OR CONDITIONS OF ANY KIND, either express or implied.
* See the License for the specific language governing permissions and
* limitations under the License.
*
************************************************************************

.subckt sg13g2_IOPadVss iovdd iovss vdd vss
Xdcndiode.dcdiode[0] vss vss dantenna l=1.26um w=27.78um
Xdcndiode.dcdiode[1] vss vss dantenna l=1.26um w=27.78um
Xdcpdiode.dcdiode[0] vss iovdd dpantenna l=1.26um w=27.78um
Xdcpdiode.dcdiode[1] vss iovdd dpantenna l=1.26um w=27.78um
.ends sg13g2_IOPadVss
