* sg13g2_IOPadOut4mA (flattened)

* Every sub-block inlined, for comparison against a flat extraction.
* Generated from sg13g2_io.spi; edit the source, not this file.

* Autogenerated file; please don't edit
* date: 2024-05-27 14:30:57.050559

************************************************************************
*
* Copyright 2024 IHP PDK Authors
*
* Licensed under the Apache License, Version 2.0 (the "License");
* you may not use this file except in compliance with the License.
* You may obtain a copy of the License at
*
*    https://www.apache.org/licenses/LICENSE-2.0
*
* Unless required by applicable law or agreed to in writing, software
* distributed under the License is distributed on an "AS IS" BASIS,
* WITHOUT WARRANTIES OR CONDITIONS OF ANY KIND, either express or implied.
* See the License for the specific language governing permissions and
* limitations under the License.
*
************************************************************************

.subckt sg13g2_IOPadOut4mA vss vdd iovss iovdd c2p pad
Xnclamp.clamp_g0 iovss ngate pad iovss sg13_hv_nmos l=0.6um w=4.4um
Xnclamp.clamp_g1 pad ngate iovss iovss sg13_hv_nmos l=0.6um w=4.4um
Xnclamp.DGATE iovss ngate dantenna l=0.64um w=0.48um
Xpclamp.clamp_g0_r0 iovdd pgate pad iovdd sg13_hv_pmos l=0.6um w=6.66um
Xpclamp.clamp_g0_r1 iovdd pgate pad iovdd sg13_hv_pmos l=0.6um w=6.66um
Xpclamp.clamp_g1_r0 pad pgate iovdd iovdd sg13_hv_pmos l=0.6um w=6.66um
Xpclamp.clamp_g1_r1 pad pgate iovdd iovdd sg13_hv_pmos l=0.6um w=6.66um
Xpclamp.DGATE pgate iovdd dpantenna l=0.64um w=0.48um
Xdcndiode.dcdiode[0] iovss pad dantenna l=1.26um w=27.78um
Xdcndiode.dcdiode[1] iovss pad dantenna l=1.26um w=27.78um
Xdcpdiode.dcdiode[0] pad iovdd dpantenna l=1.26um w=27.78um
Xdcpdiode.dcdiode[1] pad iovdd dpantenna l=1.26um w=27.78um
Xgatelu.ngate_levelup.n_i_inv gatelu.ngate_levelup.i_n c2p vss vss sg13_lv_nmos l=0.13um w=2.75um
Xgatelu.ngate_levelup.p_i_inv gatelu.ngate_levelup.i_n c2p vdd vdd sg13_lv_pmos l=0.13um w=4.75um
Xgatelu.ngate_levelup.n_lvld_n vss gatelu.ngate_levelup.i_n gatelu.ngate_levelup.lvld_n vss sg13_hv_nmos l=0.45um w=1.9um
Xgatelu.ngate_levelup.n_lvld gatelu.ngate_levelup.lvld c2p vss vss sg13_hv_nmos l=0.45um w=1.9um
Xgatelu.ngate_levelup.p_lvld_n iovdd gatelu.ngate_levelup.lvld gatelu.ngate_levelup.lvld_n iovdd sg13_hv_pmos l=0.45um w=0.3um
Xgatelu.ngate_levelup.p_lvld gatelu.ngate_levelup.lvld gatelu.ngate_levelup.lvld_n iovdd iovdd sg13_hv_pmos l=0.45um w=0.3um
Xgatelu.ngate_levelup.n_lvld_n_inv vss gatelu.ngate_levelup.lvld_n ngate vss sg13_hv_nmos l=0.45um w=1.9um
Xgatelu.ngate_levelup.p_lvld_n_inv iovdd gatelu.ngate_levelup.lvld_n ngate iovdd sg13_hv_pmos l=0.45um w=3.9um
Xgatelu.pgate_levelup.n_i_inv gatelu.pgate_levelup.i_n c2p vss vss sg13_lv_nmos l=0.13um w=2.75um
Xgatelu.pgate_levelup.p_i_inv gatelu.pgate_levelup.i_n c2p vdd vdd sg13_lv_pmos l=0.13um w=4.75um
Xgatelu.pgate_levelup.n_lvld_n vss gatelu.pgate_levelup.i_n gatelu.pgate_levelup.lvld_n vss sg13_hv_nmos l=0.45um w=1.9um
Xgatelu.pgate_levelup.n_lvld gatelu.pgate_levelup.lvld c2p vss vss sg13_hv_nmos l=0.45um w=1.9um
Xgatelu.pgate_levelup.p_lvld_n iovdd gatelu.pgate_levelup.lvld gatelu.pgate_levelup.lvld_n iovdd sg13_hv_pmos l=0.45um w=0.3um
Xgatelu.pgate_levelup.p_lvld gatelu.pgate_levelup.lvld gatelu.pgate_levelup.lvld_n iovdd iovdd sg13_hv_pmos l=0.45um w=0.3um
Xgatelu.pgate_levelup.n_lvld_n_inv vss gatelu.pgate_levelup.lvld_n pgate vss sg13_hv_nmos l=0.45um w=1.9um
Xgatelu.pgate_levelup.p_lvld_n_inv iovdd gatelu.pgate_levelup.lvld_n pgate iovdd sg13_hv_pmos l=0.45um w=3.9um
.ends sg13g2_IOPadOut4mA
