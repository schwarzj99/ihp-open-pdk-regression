* sg13g2_IOPadOut30mA (flattened)

* Every sub-block inlined, for comparison against a flat extraction.
* Generated from sg13g2_io.spi; edit the source, not this file.

* Autogenerated file; please don't edit
* date: 2024-05-27 14:30:57.050559

************************************************************************
*
* Copyright 2024 IHP PDK Authors
*
* Licensed under the Apache License, Version 2.0 (the "License");
* you may not use this file except in compliance with the License.
* You may obtain a copy of the License at
*
*    https://www.apache.org/licenses/LICENSE-2.0
*
* Unless required by applicable law or agreed to in writing, software
* distributed under the License is distributed on an "AS IS" BASIS,
* WITHOUT WARRANTIES OR CONDITIONS OF ANY KIND, either express or implied.
* See the License for the specific language governing permissions and
* limitations under the License.
*
************************************************************************

.subckt sg13g2_IOPadOut30mA c2p iovdd iovss pad vdd vss
Xnclamp.clamp_g0 vss ngate pad vss sg13_hv_nmos l=0.6um w=4.4um
Xnclamp.clamp_g1 pad ngate vss vss sg13_hv_nmos l=0.6um w=4.4um
Xnclamp.clamp_g2 vss ngate pad vss sg13_hv_nmos l=0.6um w=4.4um
Xnclamp.clamp_g3 pad ngate vss vss sg13_hv_nmos l=0.6um w=4.4um
Xnclamp.clamp_g4 vss ngate pad vss sg13_hv_nmos l=0.6um w=4.4um
Xnclamp.clamp_g5 pad ngate vss vss sg13_hv_nmos l=0.6um w=4.4um
Xnclamp.clamp_g6 vss ngate pad vss sg13_hv_nmos l=0.6um w=4.4um
Xnclamp.clamp_g7 pad ngate vss vss sg13_hv_nmos l=0.6um w=4.4um
Xnclamp.clamp_g8 vss ngate pad vss sg13_hv_nmos l=0.6um w=4.4um
Xnclamp.clamp_g9 pad ngate vss vss sg13_hv_nmos l=0.6um w=4.4um
Xnclamp.clamp_g10 vss ngate pad vss sg13_hv_nmos l=0.6um w=4.4um
Xnclamp.clamp_g11 pad ngate vss vss sg13_hv_nmos l=0.6um w=4.4um
Xnclamp.clamp_g12 vss ngate pad vss sg13_hv_nmos l=0.6um w=4.4um
Xnclamp.clamp_g13 pad ngate vss vss sg13_hv_nmos l=0.6um w=4.4um
Xnclamp.clamp_g14 vss ngate pad vss sg13_hv_nmos l=0.6um w=4.4um
Xnclamp.DGATE vss ngate dantenna l=0.78um w=0.78um
Xpclamp.clamp_g0_r0 iovdd pgate pad iovdd sg13_hv_pmos l=0.6um w=6.66um
Xpclamp.clamp_g0_r1 iovdd pgate pad iovdd sg13_hv_pmos l=0.6um w=6.66um
Xpclamp.clamp_g1_r0 pad pgate iovdd iovdd sg13_hv_pmos l=0.6um w=6.66um
Xpclamp.clamp_g1_r1 pad pgate iovdd iovdd sg13_hv_pmos l=0.6um w=6.66um
Xpclamp.clamp_g2_r0 iovdd pgate pad iovdd sg13_hv_pmos l=0.6um w=6.66um
Xpclamp.clamp_g2_r1 iovdd pgate pad iovdd sg13_hv_pmos l=0.6um w=6.66um
Xpclamp.clamp_g3_r0 pad pgate iovdd iovdd sg13_hv_pmos l=0.6um w=6.66um
Xpclamp.clamp_g3_r1 pad pgate iovdd iovdd sg13_hv_pmos l=0.6um w=6.66um
Xpclamp.clamp_g4_r0 iovdd pgate pad iovdd sg13_hv_pmos l=0.6um w=6.66um
Xpclamp.clamp_g4_r1 iovdd pgate pad iovdd sg13_hv_pmos l=0.6um w=6.66um
Xpclamp.clamp_g5_r0 pad pgate iovdd iovdd sg13_hv_pmos l=0.6um w=6.66um
Xpclamp.clamp_g5_r1 pad pgate iovdd iovdd sg13_hv_pmos l=0.6um w=6.66um
Xpclamp.clamp_g6_r0 iovdd pgate pad iovdd sg13_hv_pmos l=0.6um w=6.66um
Xpclamp.clamp_g6_r1 iovdd pgate pad iovdd sg13_hv_pmos l=0.6um w=6.66um
Xpclamp.clamp_g7_r0 pad pgate iovdd iovdd sg13_hv_pmos l=0.6um w=6.66um
Xpclamp.clamp_g7_r1 pad pgate iovdd iovdd sg13_hv_pmos l=0.6um w=6.66um
Xpclamp.clamp_g8_r0 iovdd pgate pad iovdd sg13_hv_pmos l=0.6um w=6.66um
Xpclamp.clamp_g8_r1 iovdd pgate pad iovdd sg13_hv_pmos l=0.6um w=6.66um
Xpclamp.clamp_g9_r0 pad pgate iovdd iovdd sg13_hv_pmos l=0.6um w=6.66um
Xpclamp.clamp_g9_r1 pad pgate iovdd iovdd sg13_hv_pmos l=0.6um w=6.66um
Xpclamp.clamp_g10_r0 iovdd pgate pad iovdd sg13_hv_pmos l=0.6um w=6.66um
Xpclamp.clamp_g10_r1 iovdd pgate pad iovdd sg13_hv_pmos l=0.6um w=6.66um
Xpclamp.clamp_g11_r0 pad pgate iovdd iovdd sg13_hv_pmos l=0.6um w=6.66um
Xpclamp.clamp_g11_r1 pad pgate iovdd iovdd sg13_hv_pmos l=0.6um w=6.66um
Xpclamp.clamp_g12_r0 iovdd pgate pad iovdd sg13_hv_pmos l=0.6um w=6.66um
Xpclamp.clamp_g12_r1 iovdd pgate pad iovdd sg13_hv_pmos l=0.6um w=6.66um
Xpclamp.clamp_g13_r0 pad pgate iovdd iovdd sg13_hv_pmos l=0.6um w=6.66um
Xpclamp.clamp_g13_r1 pad pgate iovdd iovdd sg13_hv_pmos l=0.6um w=6.66um
Xpclamp.clamp_g14_r0 iovdd pgate pad iovdd sg13_hv_pmos l=0.6um w=6.66um
Xpclamp.clamp_g14_r1 iovdd pgate pad iovdd sg13_hv_pmos l=0.6um w=6.66um
Xpclamp.DGATE pgate iovdd dpantenna l=0.78um w=0.78um
Xdcndiode.dcdiode[0] vss pad dantenna l=1.26um w=27.78um
Xdcndiode.dcdiode[1] vss pad dantenna l=1.26um w=27.78um
Xdcpdiode.dcdiode[0] pad iovdd dpantenna l=1.26um w=27.78um
Xdcpdiode.dcdiode[1] pad iovdd dpantenna l=1.26um w=27.78um
Xgatelu.ngate_levelup.n_i_inv gatelu.ngate_levelup.i_n c2p vss vss sg13_lv_nmos l=0.13um w=2.75um
Xgatelu.ngate_levelup.p_i_inv gatelu.ngate_levelup.i_n c2p vdd vdd sg13_lv_pmos l=0.13um w=4.75um
Xgatelu.ngate_levelup.n_lvld_n vss gatelu.ngate_levelup.i_n gatelu.ngate_levelup.lvld_n vss sg13_hv_nmos l=0.45um w=1.9um
Xgatelu.ngate_levelup.n_lvld gatelu.ngate_levelup.lvld c2p vss vss sg13_hv_nmos l=0.45um w=1.9um
Xgatelu.ngate_levelup.p_lvld_n iovdd gatelu.ngate_levelup.lvld gatelu.ngate_levelup.lvld_n iovdd sg13_hv_pmos l=0.45um w=0.3um
Xgatelu.ngate_levelup.p_lvld gatelu.ngate_levelup.lvld gatelu.ngate_levelup.lvld_n iovdd iovdd sg13_hv_pmos l=0.45um w=0.3um
Xgatelu.ngate_levelup.n_lvld_n_inv vss gatelu.ngate_levelup.lvld_n ngate vss sg13_hv_nmos l=0.45um w=1.9um
Xgatelu.ngate_levelup.p_lvld_n_inv iovdd gatelu.ngate_levelup.lvld_n ngate iovdd sg13_hv_pmos l=0.45um w=3.9um
Xgatelu.pgate_levelup.n_i_inv gatelu.pgate_levelup.i_n c2p vss vss sg13_lv_nmos l=0.13um w=2.75um
Xgatelu.pgate_levelup.p_i_inv gatelu.pgate_levelup.i_n c2p vdd vdd sg13_lv_pmos l=0.13um w=4.75um
Xgatelu.pgate_levelup.n_lvld_n vss gatelu.pgate_levelup.i_n gatelu.pgate_levelup.lvld_n vss sg13_hv_nmos l=0.45um w=1.9um
Xgatelu.pgate_levelup.n_lvld gatelu.pgate_levelup.lvld c2p vss vss sg13_hv_nmos l=0.45um w=1.9um
Xgatelu.pgate_levelup.p_lvld_n iovdd gatelu.pgate_levelup.lvld gatelu.pgate_levelup.lvld_n iovdd sg13_hv_pmos l=0.45um w=0.3um
Xgatelu.pgate_levelup.p_lvld gatelu.pgate_levelup.lvld gatelu.pgate_levelup.lvld_n iovdd iovdd sg13_hv_pmos l=0.45um w=0.3um
Xgatelu.pgate_levelup.n_lvld_n_inv vss gatelu.pgate_levelup.lvld_n pgate vss sg13_hv_nmos l=0.45um w=1.9um
Xgatelu.pgate_levelup.p_lvld_n_inv iovdd gatelu.pgate_levelup.lvld_n pgate iovdd sg13_hv_pmos l=0.45um w=3.9um
.ends sg13g2_IOPadOut30mA
