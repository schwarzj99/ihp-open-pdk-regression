* sg13g2_IOPadAnalog (flattened)

* Every sub-block inlined, for comparison against a flat extraction.
* Generated from sg13g2_io.spi; edit the source, not this file.

* Autogenerated file; please don't edit
* date: 2024-05-27 14:30:57.050559

************************************************************************
*
* Copyright 2024 IHP PDK Authors
*
* Licensed under the Apache License, Version 2.0 (the "License");
* you may not use this file except in compliance with the License.
* You may obtain a copy of the License at
*
*    https://www.apache.org/licenses/LICENSE-2.0
*
* Unless required by applicable law or agreed to in writing, software
* distributed under the License is distributed on an "AS IS" BASIS,
* WITHOUT WARRANTIES OR CONDITIONS OF ANY KIND, either express or implied.
* See the License for the specific language governing permissions and
* limitations under the License.
*
************************************************************************

.subckt sg13g2_IOPadAnalog iovdd iovss pad padbare padres vdd vss
Xnclamp.clamp_g0 vss nclamp.off pad vss sg13_hv_nmos l=0.6um w=4.4um
Xnclamp.clamp_g1 pad nclamp.off vss vss sg13_hv_nmos l=0.6um w=4.4um
Xnclamp.clamp_g2 vss nclamp.off pad vss sg13_hv_nmos l=0.6um w=4.4um
Xnclamp.clamp_g3 pad nclamp.off vss vss sg13_hv_nmos l=0.6um w=4.4um
Xnclamp.clamp_g4 vss nclamp.off pad vss sg13_hv_nmos l=0.6um w=4.4um
Xnclamp.clamp_g5 pad nclamp.off vss vss sg13_hv_nmos l=0.6um w=4.4um
Xnclamp.clamp_g6 vss nclamp.off pad vss sg13_hv_nmos l=0.6um w=4.4um
Xnclamp.clamp_g7 pad nclamp.off vss vss sg13_hv_nmos l=0.6um w=4.4um
Xnclamp.clamp_g8 vss nclamp.off pad vss sg13_hv_nmos l=0.6um w=4.4um
Xnclamp.clamp_g9 pad nclamp.off vss vss sg13_hv_nmos l=0.6um w=4.4um
Xnclamp.clamp_g10 vss nclamp.off pad vss sg13_hv_nmos l=0.6um w=4.4um
Xnclamp.clamp_g11 pad nclamp.off vss vss sg13_hv_nmos l=0.6um w=4.4um
Xnclamp.clamp_g12 vss nclamp.off pad vss sg13_hv_nmos l=0.6um w=4.4um
Xnclamp.clamp_g13 pad nclamp.off vss vss sg13_hv_nmos l=0.6um w=4.4um
Xnclamp.clamp_g14 vss nclamp.off pad vss sg13_hv_nmos l=0.6um w=4.4um
Xnclamp.clamp_g15 pad nclamp.off vss vss sg13_hv_nmos l=0.6um w=4.4um
Xnclamp.clamp_g16 vss nclamp.off pad vss sg13_hv_nmos l=0.6um w=4.4um
Xnclamp.clamp_g17 pad nclamp.off vss vss sg13_hv_nmos l=0.6um w=4.4um
Xnclamp.clamp_g18 vss nclamp.off pad vss sg13_hv_nmos l=0.6um w=4.4um
Xnclamp.clamp_g19 pad nclamp.off vss vss sg13_hv_nmos l=0.6um w=4.4um
Xnclamp.Roff vss nclamp.off vss rppd l=3.54um w=0.5um
Xpclamp.clamp_g0_r0 iovdd pclamp.off pad iovdd sg13_hv_pmos l=0.6um w=6.66um
Xpclamp.clamp_g0_r1 iovdd pclamp.off pad iovdd sg13_hv_pmos l=0.6um w=6.66um
Xpclamp.clamp_g1_r0 pad pclamp.off iovdd iovdd sg13_hv_pmos l=0.6um w=6.66um
Xpclamp.clamp_g1_r1 pad pclamp.off iovdd iovdd sg13_hv_pmos l=0.6um w=6.66um
Xpclamp.clamp_g2_r0 iovdd pclamp.off pad iovdd sg13_hv_pmos l=0.6um w=6.66um
Xpclamp.clamp_g2_r1 iovdd pclamp.off pad iovdd sg13_hv_pmos l=0.6um w=6.66um
Xpclamp.clamp_g3_r0 pad pclamp.off iovdd iovdd sg13_hv_pmos l=0.6um w=6.66um
Xpclamp.clamp_g3_r1 pad pclamp.off iovdd iovdd sg13_hv_pmos l=0.6um w=6.66um
Xpclamp.clamp_g4_r0 iovdd pclamp.off pad iovdd sg13_hv_pmos l=0.6um w=6.66um
Xpclamp.clamp_g4_r1 iovdd pclamp.off pad iovdd sg13_hv_pmos l=0.6um w=6.66um
Xpclamp.clamp_g5_r0 pad pclamp.off iovdd iovdd sg13_hv_pmos l=0.6um w=6.66um
Xpclamp.clamp_g5_r1 pad pclamp.off iovdd iovdd sg13_hv_pmos l=0.6um w=6.66um
Xpclamp.clamp_g6_r0 iovdd pclamp.off pad iovdd sg13_hv_pmos l=0.6um w=6.66um
Xpclamp.clamp_g6_r1 iovdd pclamp.off pad iovdd sg13_hv_pmos l=0.6um w=6.66um
Xpclamp.clamp_g7_r0 pad pclamp.off iovdd iovdd sg13_hv_pmos l=0.6um w=6.66um
Xpclamp.clamp_g7_r1 pad pclamp.off iovdd iovdd sg13_hv_pmos l=0.6um w=6.66um
Xpclamp.clamp_g8_r0 iovdd pclamp.off pad iovdd sg13_hv_pmos l=0.6um w=6.66um
Xpclamp.clamp_g8_r1 iovdd pclamp.off pad iovdd sg13_hv_pmos l=0.6um w=6.66um
Xpclamp.clamp_g9_r0 pad pclamp.off iovdd iovdd sg13_hv_pmos l=0.6um w=6.66um
Xpclamp.clamp_g9_r1 pad pclamp.off iovdd iovdd sg13_hv_pmos l=0.6um w=6.66um
Xpclamp.clamp_g10_r0 iovdd pclamp.off pad iovdd sg13_hv_pmos l=0.6um w=6.66um
Xpclamp.clamp_g10_r1 iovdd pclamp.off pad iovdd sg13_hv_pmos l=0.6um w=6.66um
Xpclamp.clamp_g11_r0 pad pclamp.off iovdd iovdd sg13_hv_pmos l=0.6um w=6.66um
Xpclamp.clamp_g11_r1 pad pclamp.off iovdd iovdd sg13_hv_pmos l=0.6um w=6.66um
Xpclamp.clamp_g12_r0 iovdd pclamp.off pad iovdd sg13_hv_pmos l=0.6um w=6.66um
Xpclamp.clamp_g12_r1 iovdd pclamp.off pad iovdd sg13_hv_pmos l=0.6um w=6.66um
Xpclamp.clamp_g13_r0 pad pclamp.off iovdd iovdd sg13_hv_pmos l=0.6um w=6.66um
Xpclamp.clamp_g13_r1 pad pclamp.off iovdd iovdd sg13_hv_pmos l=0.6um w=6.66um
Xpclamp.clamp_g14_r0 iovdd pclamp.off pad iovdd sg13_hv_pmos l=0.6um w=6.66um
Xpclamp.clamp_g14_r1 iovdd pclamp.off pad iovdd sg13_hv_pmos l=0.6um w=6.66um
Xpclamp.clamp_g15_r0 pad pclamp.off iovdd iovdd sg13_hv_pmos l=0.6um w=6.66um
Xpclamp.clamp_g15_r1 pad pclamp.off iovdd iovdd sg13_hv_pmos l=0.6um w=6.66um
Xpclamp.clamp_g16_r0 iovdd pclamp.off pad iovdd sg13_hv_pmos l=0.6um w=6.66um
Xpclamp.clamp_g16_r1 iovdd pclamp.off pad iovdd sg13_hv_pmos l=0.6um w=6.66um
Xpclamp.clamp_g17_r0 pad pclamp.off iovdd iovdd sg13_hv_pmos l=0.6um w=6.66um
Xpclamp.clamp_g17_r1 pad pclamp.off iovdd iovdd sg13_hv_pmos l=0.6um w=6.66um
Xpclamp.clamp_g18_r0 iovdd pclamp.off pad iovdd sg13_hv_pmos l=0.6um w=6.66um
Xpclamp.clamp_g18_r1 iovdd pclamp.off pad iovdd sg13_hv_pmos l=0.6um w=6.66um
Xpclamp.clamp_g19_r0 pad pclamp.off iovdd iovdd sg13_hv_pmos l=0.6um w=6.66um
Xpclamp.clamp_g19_r1 pad pclamp.off iovdd iovdd sg13_hv_pmos l=0.6um w=6.66um
Xpclamp.Roff iovdd pclamp.off iovdd rppd l=12.9um w=0.5um
Xdcndiode.dcdiode[0] vss pad dantenna l=1.26um w=27.78um
Xdcndiode.dcdiode[1] vss pad dantenna l=1.26um w=27.78um
Xdcpdiode.dcdiode[0] pad iovdd dpantenna l=1.26um w=27.78um
Xdcpdiode.dcdiode[1] pad iovdd dpantenna l=1.26um w=27.78um
Xsecondprot.R pad padres vss rppd l=2.0um w=1.0um
Xsecondprot.DN vss padres dantenna l=3.1um w=0.64um
Xsecondprot.DP padres iovdd dpantenna l=0.64um w=4.98um
.ends sg13g2_IOPadAnalog
