* sg13g2_IOPadIn (flattened)

* Every sub-block inlined, for comparison against a flat extraction.
* Generated from sg13g2_io.spi; edit the source, not this file.

* Autogenerated file; please don't edit
* date: 2024-05-27 14:30:57.050559

************************************************************************
*
* Copyright 2024 IHP PDK Authors
*
* Licensed under the Apache License, Version 2.0 (the "License");
* you may not use this file except in compliance with the License.
* You may obtain a copy of the License at
*
*    https://www.apache.org/licenses/LICENSE-2.0
*
* Unless required by applicable law or agreed to in writing, software
* distributed under the License is distributed on an "AS IS" BASIS,
* WITHOUT WARRANTIES OR CONDITIONS OF ANY KIND, either express or implied.
* See the License for the specific language governing permissions and
* limitations under the License.
*
************************************************************************

.subckt sg13g2_IOPadIn iovdd iovss p2c pad vdd vss
Xdcndiode.dcdiode[0] vss pad dantenna l=1.26um w=27.78um
Xdcndiode.dcdiode[1] vss pad dantenna l=1.26um w=27.78um
Xdcpdiode.dcdiode[0] pad iovdd dpantenna l=1.26um w=27.78um
Xdcpdiode.dcdiode[1] pad iovdd dpantenna l=1.26um w=27.78um
Xleveldown.n_hvinv vss leveldown.padres leveldown.padres_n vss sg13_hv_nmos l=0.45um w=2.65um
Xleveldown.p_hvinv vdd leveldown.padres leveldown.padres_n vdd sg13_hv_pmos l=0.45um w=4.65um
Xleveldown.n_lvinv p2c leveldown.padres_n vss vss sg13_lv_nmos l=0.13um w=2.75um
Xleveldown.p_lvinv p2c leveldown.padres_n vdd vdd sg13_lv_pmos l=0.13um w=4.75um
Xleveldown.secondprot.R pad leveldown.padres vss rppd l=2.0um w=1.0um
Xleveldown.secondprot.DN vss leveldown.padres dantenna l=3.1um w=0.64um
Xleveldown.secondprot.DP leveldown.padres iovdd dpantenna l=0.64um w=4.98um
.ends sg13g2_IOPadIn
