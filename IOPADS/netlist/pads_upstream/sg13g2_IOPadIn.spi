* sg13g2_IOPadIn

* Split from sg13g2_io_upstream_sub.spi on 2026-08-11; contains sg13g2_IOPadIn and its
* 9 supporting subckts. Edit the source netlist, not this file.

* Autogenerated file; please don't edit
* date: 2024-05-27 14:30:57.050559

************************************************************************
*
* Copyright 2024 IHP PDK Authors
*
* Licensed under the Apache License, Version 2.0 (the "License");
* you may not use this file except in compliance with the License.
* You may obtain a copy of the License at
*
*    https://www.apache.org/licenses/LICENSE-2.0
*
* Unless required by applicable law or agreed to in writing, software
* distributed under the License is distributed on an "AS IS" BASIS,
* WITHOUT WARRANTIES OR CONDITIONS OF ANY KIND, either express or implied.
* See the License for the specific language governing permissions and
* limitations under the License.
*
************************************************************************

* sg13g2_io_tie
.GLOBAL sub

* sg13g2_GuardRing_P576W948HFF
.subckt sg13g2_GuardRing_P576W948HFF conn

.ends sg13g2_GuardRing_P576W948HFF

* sg13g2_GuardRing_P456W948HFF
.subckt sg13g2_GuardRing_P456W948HFF conn

.ends sg13g2_GuardRing_P456W948HFF

* sg13g2_GuardRing_N1324W456HTF
.subckt sg13g2_GuardRing_N1324W456HTF conn

.ends sg13g2_GuardRing_N1324W456HTF

* sg13g2_SecondaryProtection
.subckt sg13g2_SecondaryProtection iovdd iovss pad core
RR pad core sub rppd l=2u w=1u
Xguard1 iovss sg13g2_GuardRing_P576W948HFF
DDN sub core dantenna A=1.984p P=7.48u
Xguard2 iovss sg13g2_GuardRing_P456W948HFF
DDP core iovdd dpantenna A=3.1872p P=11.24u
Xguard3 iovdd sg13g2_GuardRing_N1324W456HTF
Rtap0 iovss sub ptap1 A=9.0304p P=53.12u
.ends sg13g2_SecondaryProtection

* sg13g2_LevelDown
.subckt sg13g2_LevelDown vdd vss iovdd iovss pad core
Xsecondprot iovdd iovss pad padres sg13g2_SecondaryProtection
Mn_inv1 n1 padres iovss sub sg13_hv_nmos L=0.45u W=1.3u
Mp_inv1 iovdd padres n1 iovdd sg13_hv_pmos L=0.45u W=4.6u
Mn_inv2 iovss n1 n2 sub sg13_hv_nmos L=0.45u W=1.3u
Mp_inv2 iovdd n1 n2 iovdd sg13_hv_pmos L=0.45u W=4.6u
Mn_pd vss n2 mid sub sg13_hv_nmos L=0.45u W=2.65u
Mn_pu mid n1 vdd sub sg13_hv_nmos L=0.45u W=2.65u
Mn_core core mid vss sub sg13_lv_nmos L=0.13u W=2.75u
Mp_core core mid vdd vdd sg13_lv_pmos L=0.13u W=4.75u
Rtap0 iovss sub ptap1 A=0.804p P=5.96u
Rtap1 vss sub ptap1 A=2.019p P=14.06u
.ends sg13g2_LevelDown

* sg13g2_GuardRing_N7276W2716HFF
.subckt sg13g2_GuardRing_N7276W2716HFF conn

.ends sg13g2_GuardRing_N7276W2716HFF

* sg13g2_DCNDiode
.subckt sg13g2_DCNDiode anode cathode guard
Ddcdiode_0 anode cathode dantenna A=35.0028p P=58.08u
Ddcdiode_1 anode cathode dantenna A=35.0028p P=58.08u
Xguard guard sg13g2_GuardRing_N7276W2716HFF
Rtap0 guard anode ptap1 A=141.2964p P=221.76u
.ends sg13g2_DCNDiode

* sg13g2_GuardRing_P7276W2716HFF
.subckt sg13g2_GuardRing_P7276W2716HFF conn

.ends sg13g2_GuardRing_P7276W2716HFF

* sg13g2_DCPDiode
.subckt sg13g2_DCPDiode anode cathode guard
Ddcdiode_0 anode cathode dpantenna A=35.0028p P=58.08u
Ddcdiode_1 anode cathode dpantenna A=35.0028p P=58.08u
Xguard guard sg13g2_GuardRing_P7276W2716HFF
Rtap0 guard sub ptap1 A=33.5104p P=197.12u
.ends sg13g2_DCPDiode

* sg13g2_IOPadIn
.subckt sg13g2_IOPadIn vss vdd iovss iovdd p2c pad
Xdcndiode sub pad iovss sg13g2_DCNDiode
Xdcpdiode pad iovdd iovss sg13g2_DCPDiode
Xleveldown vdd vss iovdd iovss pad p2c sg13g2_LevelDown
Rtap0 iovss sub ptap1 A=5379.0466p P=677.04u
Rtap1 vss sub ptap1 A=21.981p P=147.74u
.ends sg13g2_IOPadIn
