* sg13g2_io

* Autogenerated file; please don't edit
* date: 2024-05-27 14:30:57.050559

************************************************************************
*
* Copyright 2024 IHP PDK Authors
*
* Licensed under the Apache License, Version 2.0 (the "License");
* you may not use this file except in compliance with the License.
* You may obtain a copy of the License at
*
*    https://www.apache.org/licenses/LICENSE-2.0
*
* Unless required by applicable law or agreed to in writing, software
* distributed under the License is distributed on an "AS IS" BASIS,
* WITHOUT WARRANTIES OR CONDITIONS OF ANY KIND, either express or implied.
* See the License for the specific language governing permissions and
* limitations under the License.
*
************************************************************************

* sg13g2_io_tie
.subckt sg13g2_io_tie vdd vss

.ends sg13g2_io_tie

* sg13g2_io_inv_x1
.subckt sg13g2_io_inv_x1 vdd vss i nq
Mnmos vss i nq vss sg13_lv_nmos L=0.13u W=3.93u
Mpmos vdd i nq vdd sg13_lv_pmos L=0.13u W=4.41u
.ends sg13g2_io_inv_x1

* sg13g2_io_nor2_x1
.subckt sg13g2_io_nor2_x1 vdd vss nq i0 i1
Mi0_nmos vss i0 nq vss sg13_lv_nmos L=0.13u W=3.93u
Mi0_pmos vdd i0 _net0 vdd sg13_lv_pmos L=0.13u W=4.41u
Mi1_nmos nq i1 vss vss sg13_lv_nmos L=0.13u W=3.93u
Mi1_pmos _net0 i1 nq vdd sg13_lv_pmos L=0.13u W=4.41u
.ends sg13g2_io_nor2_x1

* sg13g2_LevelUp
.subckt sg13g2_LevelUp vdd iovdd vss i o
Mn_i_inv i_n i vss vss sg13_lv_nmos L=0.13u W=2.75u
Mp_i_inv i_n i vdd vdd sg13_lv_pmos L=0.13u W=4.75u
Mn_lvld_n vss i lvld_n vss sg13_hv_nmos L=0.45u W=1.9u
Mn_lvld lvld i_n vss vss sg13_hv_nmos L=0.45u W=1.9u
Mp_lvld_n iovdd lvld lvld_n iovdd sg13_hv_pmos L=0.45u W=0.3u
Mp_lvld lvld lvld_n iovdd iovdd sg13_hv_pmos L=0.45u W=0.3u
Mn_lvld_n_inv vss lvld_n o vss sg13_hv_nmos L=0.45u W=1.9u
Mp_lvld_n_inv iovdd lvld_n o iovdd sg13_hv_pmos L=0.45u W=3.9u
.ends sg13g2_LevelUp

* sg13g2_io_nand2_x1
.subckt sg13g2_io_nand2_x1 vdd vss nq i0 i1
Mi0_nmos vss i0 _net0 vss sg13_lv_nmos L=0.13u W=3.93u
Mi0_pmos vdd i0 nq vdd sg13_lv_pmos L=0.13u W=4.41u
Mi1_nmos _net0 i1 nq vss sg13_lv_nmos L=0.13u W=3.93u
Mi1_pmos nq i1 vdd vdd sg13_lv_pmos L=0.13u W=4.41u
.ends sg13g2_io_nand2_x1

* sg13g2_GateDecode
.subckt sg13g2_GateDecode vdd vss iovdd core en ngate pgate
Xtieinst vdd vss sg13g2_io_tie
Xen_inv vdd vss en en_n sg13g2_io_inv_x1
Xngate_nor vdd vss ngate_core core en_n sg13g2_io_nor2_x1
Xngate_levelup vdd iovdd vss ngate_core ngate sg13g2_LevelUp
Xpgate_nand vdd vss pgate_core core en sg13g2_io_nand2_x1
Xpgate_levelup vdd iovdd vss pgate_core pgate sg13g2_LevelUp
.ends sg13g2_GateDecode

* sg13g2_GuardRing_P576W948HFF
.subckt sg13g2_GuardRing_P576W948HFF conn

.ends sg13g2_GuardRing_P576W948HFF

* sg13g2_GuardRing_P456W948HFF
.subckt sg13g2_GuardRing_P456W948HFF conn

.ends sg13g2_GuardRing_P456W948HFF

* sg13g2_GuardRing_N1324W456HTF
.subckt sg13g2_GuardRing_N1324W456HTF conn

.ends sg13g2_GuardRing_N1324W456HTF

* sg13g2_SecondaryProtection
.subckt sg13g2_SecondaryProtection iovdd iovss pad core
RR pad core iovss rppd l=2u w=1u
Xguard1 iovss sg13g2_GuardRing_P576W948HFF
DDN iovss core dantenna A=1.984p P=7.48u
Xguard2 iovss sg13g2_GuardRing_P456W948HFF
DDP core iovdd dpantenna A=3.1872p P=11.24u
Xguard3 iovdd sg13g2_GuardRing_N1324W456HTF
.ends sg13g2_SecondaryProtection

* sg13g2_LevelDown
.subckt sg13g2_LevelDown vdd vss iovdd iovss pad core
Mn_hvinv vss padres padres_n vss sg13_hv_nmos L=0.45u W=2.65u
Mp_hvinv vdd padres padres_n vdd sg13_hv_pmos L=0.45u W=4.65u
Mn_lvinv core padres_n vss vss sg13_lv_nmos L=0.13u W=2.75u
Mp_lvinv core padres_n vdd vdd sg13_lv_pmos L=0.13u W=4.75u
Xsecondprot iovdd vss pad padres sg13g2_SecondaryProtection
.ends sg13g2_LevelDown

* sg13g2_Corner
.subckt sg13g2_Corner vss vdd iovss iovdd

.ends sg13g2_Corner

* sg13g2_Filler200
.subckt sg13g2_Filler200 vss vdd iovss iovdd

.ends sg13g2_Filler200

* sg13g2_Filler400
.subckt sg13g2_Filler400 vss vdd iovss iovdd

.ends sg13g2_Filler400

* sg13g2_Filler1000
.subckt sg13g2_Filler1000 vss vdd iovss iovdd

.ends sg13g2_Filler1000

* sg13g2_Filler2000
.subckt sg13g2_Filler2000 vss vdd iovss iovdd

.ends sg13g2_Filler2000

* sg13g2_Filler4000
.subckt sg13g2_Filler4000 vss vdd iovss iovdd

.ends sg13g2_Filler4000

* sg13g2_Filler10000
.subckt sg13g2_Filler10000 vss vdd iovss iovdd

.ends sg13g2_Filler10000

* sg13g2_GuardRing_N7276W2716HFF
.subckt sg13g2_GuardRing_N7276W2716HFF conn

.ends sg13g2_GuardRing_N7276W2716HFF

* sg13g2_DCNDiode
.subckt sg13g2_DCNDiode anode cathode guard
Ddcdiode_0 anode cathode dantenna A=35.0028p P=58.08u
Ddcdiode_1 anode cathode dantenna A=35.0028p P=58.08u
Xguard guard sg13g2_GuardRing_N7276W2716HFF
.ends sg13g2_DCNDiode

* sg13g2_GuardRing_P7276W2716HFF
.subckt sg13g2_GuardRing_P7276W2716HFF conn

.ends sg13g2_GuardRing_P7276W2716HFF

* sg13g2_DCPDiode
.subckt sg13g2_DCPDiode anode cathode guard
Ddcdiode_0 anode cathode dpantenna A=35.0028p P=58.08u
Ddcdiode_1 anode cathode dpantenna A=35.0028p P=58.08u
Xguard guard sg13g2_GuardRing_P7276W2716HFF
.ends sg13g2_DCPDiode

* sg13g2_IOPadVss
* FITS TO SCH .subckt sg13g2_IOPadVss vss vdd iovss iovdd
.subckt sg13g2_IOPadVss iovdd iovss vdd vss
Xdcndiode vss vss iovdd1 sg13g2_DCNDiode
Xdcpdiode vss iovdd vss sg13g2_DCPDiode
.ends sg13g2_IOPadVss

* sg13g2_GuardRing_N16000W4884HFF
.subckt sg13g2_GuardRing_N16000W4884HFF conn

.ends sg13g2_GuardRing_N16000W4884HFF

* sg13g2_GuardRing_P15280W4164HFF
.subckt sg13g2_GuardRing_P15280W4164HFF conn

.ends sg13g2_GuardRing_P15280W4164HFF

* sg13g2_Clamp_N43N43D4R
.subckt sg13g2_Clamp_N43N43D4R iovss iovdd pad gate
Mclamp_g0_r0 iovss gate pad iovss sg13_hv_nmos L=0.6u W=4.4u
Mclamp_g0_r1 iovss gate pad iovss sg13_hv_nmos L=0.6u W=4.4u
Mclamp_g0_r2 iovss gate pad iovss sg13_hv_nmos L=0.6u W=4.4u
Mclamp_g0_r3 iovss gate pad iovss sg13_hv_nmos L=0.6u W=4.4u
Mclamp_g1_r0 pad gate iovss iovss sg13_hv_nmos L=0.6u W=4.4u
Mclamp_g1_r1 pad gate iovss iovss sg13_hv_nmos L=0.6u W=4.4u
Mclamp_g1_r2 pad gate iovss iovss sg13_hv_nmos L=0.6u W=4.4u
Mclamp_g1_r3 pad gate iovss iovss sg13_hv_nmos L=0.6u W=4.4u
Mclamp_g2_r0 iovss gate pad iovss sg13_hv_nmos L=0.6u W=4.4u
Mclamp_g2_r1 iovss gate pad iovss sg13_hv_nmos L=0.6u W=4.4u
Mclamp_g2_r2 iovss gate pad iovss sg13_hv_nmos L=0.6u W=4.4u
Mclamp_g2_r3 iovss gate pad iovss sg13_hv_nmos L=0.6u W=4.4u
Mclamp_g3_r0 pad gate iovss iovss sg13_hv_nmos L=0.6u W=4.4u
Mclamp_g3_r1 pad gate iovss iovss sg13_hv_nmos L=0.6u W=4.4u
Mclamp_g3_r2 pad gate iovss iovss sg13_hv_nmos L=0.6u W=4.4u
Mclamp_g3_r3 pad gate iovss iovss sg13_hv_nmos L=0.6u W=4.4u
Mclamp_g4_r0 iovss gate pad iovss sg13_hv_nmos L=0.6u W=4.4u
Mclamp_g4_r1 iovss gate pad iovss sg13_hv_nmos L=0.6u W=4.4u
Mclamp_g4_r2 iovss gate pad iovss sg13_hv_nmos L=0.6u W=4.4u
Mclamp_g4_r3 iovss gate pad iovss sg13_hv_nmos L=0.6u W=4.4u
Mclamp_g5_r0 pad gate iovss iovss sg13_hv_nmos L=0.6u W=4.4u
Mclamp_g5_r1 pad gate iovss iovss sg13_hv_nmos L=0.6u W=4.4u
Mclamp_g5_r2 pad gate iovss iovss sg13_hv_nmos L=0.6u W=4.4u
Mclamp_g5_r3 pad gate iovss iovss sg13_hv_nmos L=0.6u W=4.4u
Mclamp_g6_r0 iovss gate pad iovss sg13_hv_nmos L=0.6u W=4.4u
Mclamp_g6_r1 iovss gate pad iovss sg13_hv_nmos L=0.6u W=4.4u
Mclamp_g6_r2 iovss gate pad iovss sg13_hv_nmos L=0.6u W=4.4u
Mclamp_g6_r3 iovss gate pad iovss sg13_hv_nmos L=0.6u W=4.4u
Mclamp_g7_r0 pad gate iovss iovss sg13_hv_nmos L=0.6u W=4.4u
Mclamp_g7_r1 pad gate iovss iovss sg13_hv_nmos L=0.6u W=4.4u
Mclamp_g7_r2 pad gate iovss iovss sg13_hv_nmos L=0.6u W=4.4u
Mclamp_g7_r3 pad gate iovss iovss sg13_hv_nmos L=0.6u W=4.4u
Mclamp_g8_r0 iovss gate pad iovss sg13_hv_nmos L=0.6u W=4.4u
Mclamp_g8_r1 iovss gate pad iovss sg13_hv_nmos L=0.6u W=4.4u
Mclamp_g8_r2 iovss gate pad iovss sg13_hv_nmos L=0.6u W=4.4u
Mclamp_g8_r3 iovss gate pad iovss sg13_hv_nmos L=0.6u W=4.4u
Mclamp_g9_r0 pad gate iovss iovss sg13_hv_nmos L=0.6u W=4.4u
Mclamp_g9_r1 pad gate iovss iovss sg13_hv_nmos L=0.6u W=4.4u
Mclamp_g9_r2 pad gate iovss iovss sg13_hv_nmos L=0.6u W=4.4u
Mclamp_g9_r3 pad gate iovss iovss sg13_hv_nmos L=0.6u W=4.4u
Mclamp_g10_r0 iovss gate pad iovss sg13_hv_nmos L=0.6u W=4.4u
Mclamp_g10_r1 iovss gate pad iovss sg13_hv_nmos L=0.6u W=4.4u
Mclamp_g10_r2 iovss gate pad iovss sg13_hv_nmos L=0.6u W=4.4u
Mclamp_g10_r3 iovss gate pad iovss sg13_hv_nmos L=0.6u W=4.4u
Mclamp_g11_r0 pad gate iovss iovss sg13_hv_nmos L=0.6u W=4.4u
Mclamp_g11_r1 pad gate iovss iovss sg13_hv_nmos L=0.6u W=4.4u
Mclamp_g11_r2 pad gate iovss iovss sg13_hv_nmos L=0.6u W=4.4u
Mclamp_g11_r3 pad gate iovss iovss sg13_hv_nmos L=0.6u W=4.4u
Mclamp_g12_r0 iovss gate pad iovss sg13_hv_nmos L=0.6u W=4.4u
Mclamp_g12_r1 iovss gate pad iovss sg13_hv_nmos L=0.6u W=4.4u
Mclamp_g12_r2 iovss gate pad iovss sg13_hv_nmos L=0.6u W=4.4u
Mclamp_g12_r3 iovss gate pad iovss sg13_hv_nmos L=0.6u W=4.4u
Mclamp_g13_r0 pad gate iovss iovss sg13_hv_nmos L=0.6u W=4.4u
Mclamp_g13_r1 pad gate iovss iovss sg13_hv_nmos L=0.6u W=4.4u
Mclamp_g13_r2 pad gate iovss iovss sg13_hv_nmos L=0.6u W=4.4u
Mclamp_g13_r3 pad gate iovss iovss sg13_hv_nmos L=0.6u W=4.4u
Mclamp_g14_r0 iovss gate pad iovss sg13_hv_nmos L=0.6u W=4.4u
Mclamp_g14_r1 iovss gate pad iovss sg13_hv_nmos L=0.6u W=4.4u
Mclamp_g14_r2 iovss gate pad iovss sg13_hv_nmos L=0.6u W=4.4u
Mclamp_g14_r3 iovss gate pad iovss sg13_hv_nmos L=0.6u W=4.4u
Mclamp_g15_r0 pad gate iovss iovss sg13_hv_nmos L=0.6u W=4.4u
Mclamp_g15_r1 pad gate iovss iovss sg13_hv_nmos L=0.6u W=4.4u
Mclamp_g15_r2 pad gate iovss iovss sg13_hv_nmos L=0.6u W=4.4u
Mclamp_g15_r3 pad gate iovss iovss sg13_hv_nmos L=0.6u W=4.4u
Mclamp_g16_r0 iovss gate pad iovss sg13_hv_nmos L=0.6u W=4.4u
Mclamp_g16_r1 iovss gate pad iovss sg13_hv_nmos L=0.6u W=4.4u
Mclamp_g16_r2 iovss gate pad iovss sg13_hv_nmos L=0.6u W=4.4u
Mclamp_g16_r3 iovss gate pad iovss sg13_hv_nmos L=0.6u W=4.4u
Mclamp_g17_r0 pad gate iovss iovss sg13_hv_nmos L=0.6u W=4.4u
Mclamp_g17_r1 pad gate iovss iovss sg13_hv_nmos L=0.6u W=4.4u
Mclamp_g17_r2 pad gate iovss iovss sg13_hv_nmos L=0.6u W=4.4u
Mclamp_g17_r3 pad gate iovss iovss sg13_hv_nmos L=0.6u W=4.4u
Mclamp_g18_r0 iovss gate pad iovss sg13_hv_nmos L=0.6u W=4.4u
Mclamp_g18_r1 iovss gate pad iovss sg13_hv_nmos L=0.6u W=4.4u
Mclamp_g18_r2 iovss gate pad iovss sg13_hv_nmos L=0.6u W=4.4u
Mclamp_g18_r3 iovss gate pad iovss sg13_hv_nmos L=0.6u W=4.4u
Mclamp_g19_r0 pad gate iovss iovss sg13_hv_nmos L=0.6u W=4.4u
Mclamp_g19_r1 pad gate iovss iovss sg13_hv_nmos L=0.6u W=4.4u
Mclamp_g19_r2 pad gate iovss iovss sg13_hv_nmos L=0.6u W=4.4u
Mclamp_g19_r3 pad gate iovss iovss sg13_hv_nmos L=0.6u W=4.4u
Mclamp_g20_r0 iovss gate pad iovss sg13_hv_nmos L=0.6u W=4.4u
Mclamp_g20_r1 iovss gate pad iovss sg13_hv_nmos L=0.6u W=4.4u
Mclamp_g20_r2 iovss gate pad iovss sg13_hv_nmos L=0.6u W=4.4u
Mclamp_g20_r3 iovss gate pad iovss sg13_hv_nmos L=0.6u W=4.4u
Mclamp_g21_r0 pad gate iovss iovss sg13_hv_nmos L=0.6u W=4.4u
Mclamp_g21_r1 pad gate iovss iovss sg13_hv_nmos L=0.6u W=4.4u
Mclamp_g21_r2 pad gate iovss iovss sg13_hv_nmos L=0.6u W=4.4u
Mclamp_g21_r3 pad gate iovss iovss sg13_hv_nmos L=0.6u W=4.4u
Mclamp_g22_r0 iovss gate pad iovss sg13_hv_nmos L=0.6u W=4.4u
Mclamp_g22_r1 iovss gate pad iovss sg13_hv_nmos L=0.6u W=4.4u
Mclamp_g22_r2 iovss gate pad iovss sg13_hv_nmos L=0.6u W=4.4u
Mclamp_g22_r3 iovss gate pad iovss sg13_hv_nmos L=0.6u W=4.4u
Mclamp_g23_r0 pad gate iovss iovss sg13_hv_nmos L=0.6u W=4.4u
Mclamp_g23_r1 pad gate iovss iovss sg13_hv_nmos L=0.6u W=4.4u
Mclamp_g23_r2 pad gate iovss iovss sg13_hv_nmos L=0.6u W=4.4u
Mclamp_g23_r3 pad gate iovss iovss sg13_hv_nmos L=0.6u W=4.4u
Mclamp_g24_r0 iovss gate pad iovss sg13_hv_nmos L=0.6u W=4.4u
Mclamp_g24_r1 iovss gate pad iovss sg13_hv_nmos L=0.6u W=4.4u
Mclamp_g24_r2 iovss gate pad iovss sg13_hv_nmos L=0.6u W=4.4u
Mclamp_g24_r3 iovss gate pad iovss sg13_hv_nmos L=0.6u W=4.4u
Mclamp_g25_r0 pad gate iovss iovss sg13_hv_nmos L=0.6u W=4.4u
Mclamp_g25_r1 pad gate iovss iovss sg13_hv_nmos L=0.6u W=4.4u
Mclamp_g25_r2 pad gate iovss iovss sg13_hv_nmos L=0.6u W=4.4u
Mclamp_g25_r3 pad gate iovss iovss sg13_hv_nmos L=0.6u W=4.4u
Mclamp_g26_r0 iovss gate pad iovss sg13_hv_nmos L=0.6u W=4.4u
Mclamp_g26_r1 iovss gate pad iovss sg13_hv_nmos L=0.6u W=4.4u
Mclamp_g26_r2 iovss gate pad iovss sg13_hv_nmos L=0.6u W=4.4u
Mclamp_g26_r3 iovss gate pad iovss sg13_hv_nmos L=0.6u W=4.4u
Mclamp_g27_r0 pad gate iovss iovss sg13_hv_nmos L=0.6u W=4.4u
Mclamp_g27_r1 pad gate iovss iovss sg13_hv_nmos L=0.6u W=4.4u
Mclamp_g27_r2 pad gate iovss iovss sg13_hv_nmos L=0.6u W=4.4u
Mclamp_g27_r3 pad gate iovss iovss sg13_hv_nmos L=0.6u W=4.4u
Mclamp_g28_r0 iovss gate pad iovss sg13_hv_nmos L=0.6u W=4.4u
Mclamp_g28_r1 iovss gate pad iovss sg13_hv_nmos L=0.6u W=4.4u
Mclamp_g28_r2 iovss gate pad iovss sg13_hv_nmos L=0.6u W=4.4u
Mclamp_g28_r3 iovss gate pad iovss sg13_hv_nmos L=0.6u W=4.4u
Mclamp_g29_r0 pad gate iovss iovss sg13_hv_nmos L=0.6u W=4.4u
Mclamp_g29_r1 pad gate iovss iovss sg13_hv_nmos L=0.6u W=4.4u
Mclamp_g29_r2 pad gate iovss iovss sg13_hv_nmos L=0.6u W=4.4u
Mclamp_g29_r3 pad gate iovss iovss sg13_hv_nmos L=0.6u W=4.4u
Mclamp_g30_r0 iovss gate pad iovss sg13_hv_nmos L=0.6u W=4.4u
Mclamp_g30_r1 iovss gate pad iovss sg13_hv_nmos L=0.6u W=4.4u
Mclamp_g30_r2 iovss gate pad iovss sg13_hv_nmos L=0.6u W=4.4u
Mclamp_g30_r3 iovss gate pad iovss sg13_hv_nmos L=0.6u W=4.4u
Mclamp_g31_r0 pad gate iovss iovss sg13_hv_nmos L=0.6u W=4.4u
Mclamp_g31_r1 pad gate iovss iovss sg13_hv_nmos L=0.6u W=4.4u
Mclamp_g31_r2 pad gate iovss iovss sg13_hv_nmos L=0.6u W=4.4u
Mclamp_g31_r3 pad gate iovss iovss sg13_hv_nmos L=0.6u W=4.4u
Mclamp_g32_r0 iovss gate pad iovss sg13_hv_nmos L=0.6u W=4.4u
Mclamp_g32_r1 iovss gate pad iovss sg13_hv_nmos L=0.6u W=4.4u
Mclamp_g32_r2 iovss gate pad iovss sg13_hv_nmos L=0.6u W=4.4u
Mclamp_g32_r3 iovss gate pad iovss sg13_hv_nmos L=0.6u W=4.4u
Mclamp_g33_r0 pad gate iovss iovss sg13_hv_nmos L=0.6u W=4.4u
Mclamp_g33_r1 pad gate iovss iovss sg13_hv_nmos L=0.6u W=4.4u
Mclamp_g33_r2 pad gate iovss iovss sg13_hv_nmos L=0.6u W=4.4u
Mclamp_g33_r3 pad gate iovss iovss sg13_hv_nmos L=0.6u W=4.4u
Mclamp_g34_r0 iovss gate pad iovss sg13_hv_nmos L=0.6u W=4.4u
Mclamp_g34_r1 iovss gate pad iovss sg13_hv_nmos L=0.6u W=4.4u
Mclamp_g34_r2 iovss gate pad iovss sg13_hv_nmos L=0.6u W=4.4u
Mclamp_g34_r3 iovss gate pad iovss sg13_hv_nmos L=0.6u W=4.4u
Mclamp_g35_r0 pad gate iovss iovss sg13_hv_nmos L=0.6u W=4.4u
Mclamp_g35_r1 pad gate iovss iovss sg13_hv_nmos L=0.6u W=4.4u
Mclamp_g35_r2 pad gate iovss iovss sg13_hv_nmos L=0.6u W=4.4u
Mclamp_g35_r3 pad gate iovss iovss sg13_hv_nmos L=0.6u W=4.4u
Mclamp_g36_r0 iovss gate pad iovss sg13_hv_nmos L=0.6u W=4.4u
Mclamp_g36_r1 iovss gate pad iovss sg13_hv_nmos L=0.6u W=4.4u
Mclamp_g36_r2 iovss gate pad iovss sg13_hv_nmos L=0.6u W=4.4u
Mclamp_g36_r3 iovss gate pad iovss sg13_hv_nmos L=0.6u W=4.4u
Mclamp_g37_r0 pad gate iovss iovss sg13_hv_nmos L=0.6u W=4.4u
Mclamp_g37_r1 pad gate iovss iovss sg13_hv_nmos L=0.6u W=4.4u
Mclamp_g37_r2 pad gate iovss iovss sg13_hv_nmos L=0.6u W=4.4u
Mclamp_g37_r3 pad gate iovss iovss sg13_hv_nmos L=0.6u W=4.4u
Mclamp_g38_r0 iovss gate pad iovss sg13_hv_nmos L=0.6u W=4.4u
Mclamp_g38_r1 iovss gate pad iovss sg13_hv_nmos L=0.6u W=4.4u
Mclamp_g38_r2 iovss gate pad iovss sg13_hv_nmos L=0.6u W=4.4u
Mclamp_g38_r3 iovss gate pad iovss sg13_hv_nmos L=0.6u W=4.4u
Mclamp_g39_r0 pad gate iovss iovss sg13_hv_nmos L=0.6u W=4.4u
Mclamp_g39_r1 pad gate iovss iovss sg13_hv_nmos L=0.6u W=4.4u
Mclamp_g39_r2 pad gate iovss iovss sg13_hv_nmos L=0.6u W=4.4u
Mclamp_g39_r3 pad gate iovss iovss sg13_hv_nmos L=0.6u W=4.4u
Mclamp_g40_r0 iovss gate pad iovss sg13_hv_nmos L=0.6u W=4.4u
Mclamp_g40_r1 iovss gate pad iovss sg13_hv_nmos L=0.6u W=4.4u
Mclamp_g40_r2 iovss gate pad iovss sg13_hv_nmos L=0.6u W=4.4u
Mclamp_g40_r3 iovss gate pad iovss sg13_hv_nmos L=0.6u W=4.4u
Mclamp_g41_r0 pad gate iovss iovss sg13_hv_nmos L=0.6u W=4.4u
Mclamp_g41_r1 pad gate iovss iovss sg13_hv_nmos L=0.6u W=4.4u
Mclamp_g41_r2 pad gate iovss iovss sg13_hv_nmos L=0.6u W=4.4u
Mclamp_g41_r3 pad gate iovss iovss sg13_hv_nmos L=0.6u W=4.4u
Mclamp_g42_r0 iovss gate pad iovss sg13_hv_nmos L=0.6u W=4.4u
Mclamp_g42_r1 iovss gate pad iovss sg13_hv_nmos L=0.6u W=4.4u
Mclamp_g42_r2 iovss gate pad iovss sg13_hv_nmos L=0.6u W=4.4u
Mclamp_g42_r3 iovss gate pad iovss sg13_hv_nmos L=0.6u W=4.4u
XOuterRing iovdd sg13g2_GuardRing_N16000W4884HFF
XInnerRing iovss sg13g2_GuardRing_P15280W4164HFF
DDGATE iovss gate dantenna A=0.2304p P=1.92u
.ends sg13g2_Clamp_N43N43D4R

* sg13g2_RCClampResistor
.subckt sg13g2_RCClampResistor pin1 pin2 sub
Rres_fing_0 pin1 conn_0_1 sub rppd l=20u w=1u
Rres_fing_1 conn_0_1 conn_1_2 sub rppd l=20u w=1u
Rres_fing_2 conn_1_2 conn_2_3 sub rppd l=20u w=1u
Rres_fing_3 conn_2_3 conn_3_4 sub rppd l=20u w=1u
Rres_fing_4 conn_3_4 conn_4_5 sub rppd l=20u w=1u
Rres_fing_5 conn_4_5 conn_5_6 sub rppd l=20u w=1u
Rres_fing_6 conn_5_6 conn_6_7 sub rppd l=20u w=1u
Rres_fing_7 conn_6_7 conn_7_8 sub rppd l=20u w=1u
Rres_fing_8 conn_7_8 conn_8_9 sub rppd l=20u w=1u
Rres_fing_9 conn_8_9 conn_9_10 sub rppd l=20u w=1u
Rres_fing_10 conn_9_10 conn_10_11 sub rppd l=20u w=1u
Rres_fing_11 conn_10_11 conn_11_12 sub rppd l=20u w=1u
Rres_fing_12 conn_11_12 conn_12_13 sub rppd l=20u w=1u
Rres_fing_13 conn_12_13 conn_13_14 sub rppd l=20u w=1u
Rres_fing_14 conn_13_14 conn_14_15 sub rppd l=20u w=1u
Rres_fing_15 conn_14_15 conn_15_16 sub rppd l=20u w=1u
Rres_fing_16 conn_15_16 conn_16_17 sub rppd l=20u w=1u
Rres_fing_17 conn_16_17 conn_17_18 sub rppd l=20u w=1u
Rres_fing_18 conn_17_18 conn_18_19 sub rppd l=20u w=1u
Rres_fing_19 conn_18_19 conn_19_20 sub rppd l=20u w=1u
Rres_fing_20 conn_19_20 conn_20_21 sub rppd l=20u w=1u
Rres_fing_21 conn_20_21 conn_21_22 sub rppd l=20u w=1u
Rres_fing_22 conn_21_22 conn_22_23 sub rppd l=20u w=1u
Rres_fing_23 conn_22_23 conn_23_24 sub rppd l=20u w=1u
Rres_fing_24 conn_23_24 conn_24_25 sub rppd l=20u w=1u
Rres_fing_25 conn_24_25 pin2 sub rppd l=20u w=1u
.ends sg13g2_RCClampResistor

* sg13g2_GuardRing_P16000W4466HFT
.subckt sg13g2_GuardRing_P16000W4466HFT conn

.ends sg13g2_GuardRing_P16000W4466HFT

* sg13g2_GuardRing_N9472W2216HTT
.subckt sg13g2_GuardRing_N9472W2216HTT conn

.ends sg13g2_GuardRing_N9472W2216HTT

* sg13g2_RCClampInverter
.subckt sg13g2_RCClampInverter supply iovss in out
Mcapmos0_r0 iovss in iovss iovss sg13_hv_nmos L=9.5u W=9u
Mcapmos1_r0 iovss in iovss iovss sg13_hv_nmos L=9.5u W=9u
Mcapmos2_r0 iovss in iovss iovss sg13_hv_nmos L=9.5u W=9u
Mcapmos3_r0 iovss in iovss iovss sg13_hv_nmos L=9.5u W=9u
Mcapmos4_r0 iovss in iovss iovss sg13_hv_nmos L=9.5u W=9u
Mcapmos5_r0 iovss in iovss iovss sg13_hv_nmos L=9.5u W=9u
Mcapmos6_r0 iovss in iovss iovss sg13_hv_nmos L=9.5u W=9u
Mnmos0_r0 iovss in out iovss sg13_hv_nmos L=0.5u W=9u
Mnmos1_r0 out in iovss iovss sg13_hv_nmos L=0.5u W=9u
Mnmos2_r0 iovss in out iovss sg13_hv_nmos L=0.5u W=9u
Mnmos3_r0 out in iovss iovss sg13_hv_nmos L=0.5u W=9u
Mnmos4_r0 iovss in out iovss sg13_hv_nmos L=0.5u W=9u
Mnmos5_r0 out in iovss iovss sg13_hv_nmos L=0.5u W=9u
Mcapmos0_r1 iovss in iovss iovss sg13_hv_nmos L=9.5u W=9u
Mcapmos1_r1 iovss in iovss iovss sg13_hv_nmos L=9.5u W=9u
Mcapmos2_r1 iovss in iovss iovss sg13_hv_nmos L=9.5u W=9u
Mcapmos3_r1 iovss in iovss iovss sg13_hv_nmos L=9.5u W=9u
Mcapmos4_r1 iovss in iovss iovss sg13_hv_nmos L=9.5u W=9u
Mcapmos5_r1 iovss in iovss iovss sg13_hv_nmos L=9.5u W=9u
Mcapmos6_r1 iovss in iovss iovss sg13_hv_nmos L=9.5u W=9u
Mnmos0_r1 iovss in out iovss sg13_hv_nmos L=0.5u W=9u
Mnmos1_r1 out in iovss iovss sg13_hv_nmos L=0.5u W=9u
Mnmos2_r1 iovss in out iovss sg13_hv_nmos L=0.5u W=9u
Mnmos3_r1 out in iovss iovss sg13_hv_nmos L=0.5u W=9u
Mnmos4_r1 iovss in out iovss sg13_hv_nmos L=0.5u W=9u
Mnmos5_r1 out in iovss iovss sg13_hv_nmos L=0.5u W=9u
Xnmosguardring iovss sg13g2_GuardRing_P16000W4466HFT
Mpmos0_r0 supply in out supply sg13_hv_pmos L=0.5u W=7u
Mpmos1_r0 out in supply supply sg13_hv_pmos L=0.5u W=7u
Mpmos2_r0 supply in out supply sg13_hv_pmos L=0.5u W=7u
Mpmos3_r0 out in supply supply sg13_hv_pmos L=0.5u W=7u
Mpmos4_r0 supply in out supply sg13_hv_pmos L=0.5u W=7u
Mpmos5_r0 out in supply supply sg13_hv_pmos L=0.5u W=7u
Mpmos6_r0 supply in out supply sg13_hv_pmos L=0.5u W=7u
Mpmos7_r0 out in supply supply sg13_hv_pmos L=0.5u W=7u
Mpmos8_r0 supply in out supply sg13_hv_pmos L=0.5u W=7u
Mpmos9_r0 out in supply supply sg13_hv_pmos L=0.5u W=7u
Mpmos10_r0 supply in out supply sg13_hv_pmos L=0.5u W=7u
Mpmos11_r0 out in supply supply sg13_hv_pmos L=0.5u W=7u
Mpmos12_r0 supply in out supply sg13_hv_pmos L=0.5u W=7u
Mpmos13_r0 out in supply supply sg13_hv_pmos L=0.5u W=7u
Mpmos14_r0 supply in out supply sg13_hv_pmos L=0.5u W=7u
Mpmos15_r0 out in supply supply sg13_hv_pmos L=0.5u W=7u
Mpmos16_r0 supply in out supply sg13_hv_pmos L=0.5u W=7u
Mpmos17_r0 out in supply supply sg13_hv_pmos L=0.5u W=7u
Mpmos18_r0 supply in out supply sg13_hv_pmos L=0.5u W=7u
Mpmos19_r0 out in supply supply sg13_hv_pmos L=0.5u W=7u
Mpmos20_r0 supply in out supply sg13_hv_pmos L=0.5u W=7u
Mpmos21_r0 out in supply supply sg13_hv_pmos L=0.5u W=7u
Mpmos22_r0 supply in out supply sg13_hv_pmos L=0.5u W=7u
Mpmos23_r0 out in supply supply sg13_hv_pmos L=0.5u W=7u
Mpmos24_r0 supply in out supply sg13_hv_pmos L=0.5u W=7u
Mpmos25_r0 out in supply supply sg13_hv_pmos L=0.5u W=7u
Mpmos26_r0 supply in out supply sg13_hv_pmos L=0.5u W=7u
Mpmos27_r0 out in supply supply sg13_hv_pmos L=0.5u W=7u
Mpmos28_r0 supply in out supply sg13_hv_pmos L=0.5u W=7u
Mpmos29_r0 out in supply supply sg13_hv_pmos L=0.5u W=7u
Mpmos30_r0 supply in out supply sg13_hv_pmos L=0.5u W=7u
Mpmos31_r0 out in supply supply sg13_hv_pmos L=0.5u W=7u
Mpmos32_r0 supply in out supply sg13_hv_pmos L=0.5u W=7u
Mpmos33_r0 out in supply supply sg13_hv_pmos L=0.5u W=7u
Mpmos34_r0 supply in out supply sg13_hv_pmos L=0.5u W=7u
Mpmos35_r0 out in supply supply sg13_hv_pmos L=0.5u W=7u
Mpmos36_r0 supply in out supply sg13_hv_pmos L=0.5u W=7u
Mpmos37_r0 out in supply supply sg13_hv_pmos L=0.5u W=7u
Mpmos38_r0 supply in out supply sg13_hv_pmos L=0.5u W=7u
Mpmos39_r0 out in supply supply sg13_hv_pmos L=0.5u W=7u
Mpmos40_r0 supply in out supply sg13_hv_pmos L=0.5u W=7u
Mpmos41_r0 out in supply supply sg13_hv_pmos L=0.5u W=7u
Mpmos42_r0 supply in out supply sg13_hv_pmos L=0.5u W=7u
Mpmos43_r0 out in supply supply sg13_hv_pmos L=0.5u W=7u
Mpmos44_r0 supply in out supply sg13_hv_pmos L=0.5u W=7u
Mpmos45_r0 out in supply supply sg13_hv_pmos L=0.5u W=7u
Mpmos46_r0 supply in out supply sg13_hv_pmos L=0.5u W=7u
Mpmos47_r0 out in supply supply sg13_hv_pmos L=0.5u W=7u
Mpmos48_r0 supply in out supply sg13_hv_pmos L=0.5u W=7u
Mpmos49_r0 out in supply supply sg13_hv_pmos L=0.5u W=7u
Xpmosguardring supply sg13g2_GuardRing_N9472W2216HTT
.ends sg13g2_RCClampInverter

* sg13g2_GuardRing_N16000W6624HFF
.subckt sg13g2_GuardRing_N16000W6624HFF conn

.ends sg13g2_GuardRing_N16000W6624HFF

* sg13g2_IOPadVdd
* FITS TO SCH .subckt sg13g2_IOPadVdd vss vdd iovss iovdd
.subckt sg13g2_IOPadVdd iovdd iovss vdd vss
Xnclamp vss iovdd vdd ngate sg13g2_Clamp_N43N43D4R
Xrcres vdd res_cap vss sg13g2_RCClampResistor
Xrcinv vdd vss res_cap ngate sg13g2_RCClampInverter
Xpad_guard vss sg13g2_GuardRing_N16000W6624HFF
.ends sg13g2_IOPadVdd

* sg13g2_IOPadIn
* FITS TO SCH .subckt sg13g2_IOPadIn vss vdd iovss iovdd p2c pad
.subckt sg13g2_IOPadIn iovdd iovss p2c pad vdd vss
Xdcndiode vss pad iovdd1 sg13g2_DCNDiode
Xdcpdiode pad iovdd vss sg13g2_DCPDiode
Xleveldown vdd vss iovdd vss pad p2c sg13g2_LevelDown
.ends sg13g2_IOPadIn

* sg13g2_GuardRing_N16000W1980HFF
.subckt sg13g2_GuardRing_N16000W1980HFF conn

.ends sg13g2_GuardRing_N16000W1980HFF

* sg13g2_GuardRing_P15280W1260HFF
.subckt sg13g2_GuardRing_P15280W1260HFF conn

.ends sg13g2_GuardRing_P15280W1260HFF

* sg13g2_Clamp_N2N2D
.subckt sg13g2_Clamp_N2N2D iovss iovdd pad gate
Mclamp_g0 iovss gate pad iovss sg13_hv_nmos L=0.6u W=4.4u
Mclamp_g1 pad gate iovss iovss sg13_hv_nmos L=0.6u W=4.4u
XOuterRing iovdd sg13g2_GuardRing_N16000W1980HFF
XInnerRing iovss sg13g2_GuardRing_P15280W1260HFF
DDGATE iovss gate dantenna A=0.3072p P=2.24u
.ends sg13g2_Clamp_N2N2D

* sg13g2_GuardRing_P16000W3852HFF
.subckt sg13g2_GuardRing_P16000W3852HFF conn

.ends sg13g2_GuardRing_P16000W3852HFF

* sg13g2_GuardRing_N15280W3132HTF
.subckt sg13g2_GuardRing_N15280W3132HTF conn

.ends sg13g2_GuardRing_N15280W3132HTF

* sg13g2_Clamp_P2N2D
.subckt sg13g2_Clamp_P2N2D iovss iovdd pad gate
Mclamp_g0_r0 iovdd gate pad iovdd sg13_hv_pmos L=0.6u W=6.66u
Mclamp_g0_r1 iovdd gate pad iovdd sg13_hv_pmos L=0.6u W=6.66u
Mclamp_g1_r0 pad gate iovdd iovdd sg13_hv_pmos L=0.6u W=6.66u
Mclamp_g1_r1 pad gate iovdd iovdd sg13_hv_pmos L=0.6u W=6.66u
XOuterRing iovss sg13g2_GuardRing_P16000W3852HFF
XInnerRing iovdd sg13g2_GuardRing_N15280W3132HTF
DDGATE gate iovdd dpantenna A=0.3072p P=2.24u
.ends sg13g2_Clamp_P2N2D

* sg13g2_LevelUpInv
.subckt sg13g2_LevelUpInv vdd iovdd vss i o
Mn_i_inv i_n i vss vss sg13_lv_nmos L=0.13u W=2.75u
Mp_i_inv i_n i vdd vdd sg13_lv_pmos L=0.13u W=4.75u
Mn_lvld_n vss i_n lvld_n vss sg13_hv_nmos L=0.45u W=1.9u
Mn_lvld lvld i vss vss sg13_hv_nmos L=0.45u W=1.9u
Mp_lvld_n iovdd lvld lvld_n iovdd sg13_hv_pmos L=0.45u W=0.3u
Mp_lvld lvld lvld_n iovdd iovdd sg13_hv_pmos L=0.45u W=0.3u
Mn_lvld_n_inv vss lvld_n o vss sg13_hv_nmos L=0.45u W=1.9u
Mp_lvld_n_inv iovdd lvld_n o iovdd sg13_hv_pmos L=0.45u W=3.9u
.ends sg13g2_LevelUpInv

* sg13g2_GateLevelUpInv
.subckt sg13g2_GateLevelUpInv vdd vss iovdd core ngate pgate
Xngate_levelup vdd iovdd vss core ngate sg13g2_LevelUpInv
Xpgate_levelup vdd iovdd vss core pgate sg13g2_LevelUpInv
.ends sg13g2_GateLevelUpInv

* sg13g2_IOPadOut4mA
.subckt sg13g2_IOPadOut4mA vss vdd iovss iovdd c2p pad
Xnclamp iovss iovdd pad ngate sg13g2_Clamp_N2N2D
Xpclamp iovss iovdd pad pgate sg13g2_Clamp_P2N2D
Xdcndiode iovss pad iovdd sg13g2_DCNDiode
Xdcpdiode pad iovdd iovss sg13g2_DCPDiode
Xgatelu vdd vss iovdd c2p ngate pgate sg13g2_GateLevelUpInv
.ends sg13g2_IOPadOut4mA

* sg13g2_Clamp_N8N8D
.subckt sg13g2_Clamp_N8N8D iovss iovdd pad gate
Mclamp_g0 iovss gate pad iovss sg13_hv_nmos L=0.6u W=4.4u
Mclamp_g1 pad gate iovss iovss sg13_hv_nmos L=0.6u W=4.4u
Mclamp_g2 iovss gate pad iovss sg13_hv_nmos L=0.6u W=4.4u
Mclamp_g3 pad gate iovss iovss sg13_hv_nmos L=0.6u W=4.4u
Mclamp_g4 iovss gate pad iovss sg13_hv_nmos L=0.6u W=4.4u
Mclamp_g5 pad gate iovss iovss sg13_hv_nmos L=0.6u W=4.4u
Mclamp_g6 iovss gate pad iovss sg13_hv_nmos L=0.6u W=4.4u
Mclamp_g7 pad gate iovss iovss sg13_hv_nmos L=0.6u W=4.4u
XOuterRing iovdd sg13g2_GuardRing_N16000W1980HFF
XInnerRing iovss sg13g2_GuardRing_P15280W1260HFF
DDGATE iovss gate dantenna A=0.3072p P=2.24u
.ends sg13g2_Clamp_N8N8D

* sg13g2_Clamp_P8N8D
.subckt sg13g2_Clamp_P8N8D iovss iovdd pad gate
Mclamp_g0_r0 iovdd gate pad iovdd sg13_hv_pmos L=0.6u W=6.66u
Mclamp_g0_r1 iovdd gate pad iovdd sg13_hv_pmos L=0.6u W=6.66u
Mclamp_g1_r0 pad gate iovdd iovdd sg13_hv_pmos L=0.6u W=6.66u
Mclamp_g1_r1 pad gate iovdd iovdd sg13_hv_pmos L=0.6u W=6.66u
Mclamp_g2_r0 iovdd gate pad iovdd sg13_hv_pmos L=0.6u W=6.66u
Mclamp_g2_r1 iovdd gate pad iovdd sg13_hv_pmos L=0.6u W=6.66u
Mclamp_g3_r0 pad gate iovdd iovdd sg13_hv_pmos L=0.6u W=6.66u
Mclamp_g3_r1 pad gate iovdd iovdd sg13_hv_pmos L=0.6u W=6.66u
Mclamp_g4_r0 iovdd gate pad iovdd sg13_hv_pmos L=0.6u W=6.66u
Mclamp_g4_r1 iovdd gate pad iovdd sg13_hv_pmos L=0.6u W=6.66u
Mclamp_g5_r0 pad gate iovdd iovdd sg13_hv_pmos L=0.6u W=6.66u
Mclamp_g5_r1 pad gate iovdd iovdd sg13_hv_pmos L=0.6u W=6.66u
Mclamp_g6_r0 iovdd gate pad iovdd sg13_hv_pmos L=0.6u W=6.66u
Mclamp_g6_r1 iovdd gate pad iovdd sg13_hv_pmos L=0.6u W=6.66u
Mclamp_g7_r0 pad gate iovdd iovdd sg13_hv_pmos L=0.6u W=6.66u
Mclamp_g7_r1 pad gate iovdd iovdd sg13_hv_pmos L=0.6u W=6.66u
XOuterRing iovss sg13g2_GuardRing_P16000W3852HFF
XInnerRing iovdd sg13g2_GuardRing_N15280W3132HTF
DDGATE gate iovdd dpantenna A=0.3072p P=2.24u
.ends sg13g2_Clamp_P8N8D

* sg13g2_IOPadOut16mA
.subckt sg13g2_IOPadOut16mA vss vdd iovss iovdd c2p pad
Xnclamp iovss iovdd pad ngate sg13g2_Clamp_N8N8D
Xpclamp iovss iovdd pad pgate sg13g2_Clamp_P8N8D
Xdcndiode iovss pad iovdd sg13g2_DCNDiode
Xdcpdiode pad iovdd iovss sg13g2_DCPDiode
Xgatelu vdd vss iovdd c2p ngate pgate sg13g2_GateLevelUpInv
.ends sg13g2_IOPadOut16mA

* sg13g2_Clamp_N15N15D
.subckt sg13g2_Clamp_N15N15D iovss iovdd pad gate
Mclamp_g0 iovss gate pad iovss sg13_hv_nmos L=0.6u W=4.4u
Mclamp_g1 pad gate iovss iovss sg13_hv_nmos L=0.6u W=4.4u
Mclamp_g2 iovss gate pad iovss sg13_hv_nmos L=0.6u W=4.4u
Mclamp_g3 pad gate iovss iovss sg13_hv_nmos L=0.6u W=4.4u
Mclamp_g4 iovss gate pad iovss sg13_hv_nmos L=0.6u W=4.4u
Mclamp_g5 pad gate iovss iovss sg13_hv_nmos L=0.6u W=4.4u
Mclamp_g6 iovss gate pad iovss sg13_hv_nmos L=0.6u W=4.4u
Mclamp_g7 pad gate iovss iovss sg13_hv_nmos L=0.6u W=4.4u
Mclamp_g8 iovss gate pad iovss sg13_hv_nmos L=0.6u W=4.4u
Mclamp_g9 pad gate iovss iovss sg13_hv_nmos L=0.6u W=4.4u
Mclamp_g10 iovss gate pad iovss sg13_hv_nmos L=0.6u W=4.4u
Mclamp_g11 pad gate iovss iovss sg13_hv_nmos L=0.6u W=4.4u
Mclamp_g12 iovss gate pad iovss sg13_hv_nmos L=0.6u W=4.4u
Mclamp_g13 pad gate iovss iovss sg13_hv_nmos L=0.6u W=4.4u
Mclamp_g14 iovss gate pad iovss sg13_hv_nmos L=0.6u W=4.4u
XOuterRing iovdd sg13g2_GuardRing_N16000W1980HFF
XInnerRing iovss sg13g2_GuardRing_P15280W1260HFF
DDGATE iovss gate dantenna A=0.6084p P=3.12u
.ends sg13g2_Clamp_N15N15D

* sg13g2_Clamp_P15N15D
.subckt sg13g2_Clamp_P15N15D iovss iovdd pad gate
Mclamp_g0_r0 iovdd gate pad iovdd sg13_hv_pmos L=0.6u W=6.66u
Mclamp_g0_r1 iovdd gate pad iovdd sg13_hv_pmos L=0.6u W=6.66u
Mclamp_g1_r0 pad gate iovdd iovdd sg13_hv_pmos L=0.6u W=6.66u
Mclamp_g1_r1 pad gate iovdd iovdd sg13_hv_pmos L=0.6u W=6.66u
Mclamp_g2_r0 iovdd gate pad iovdd sg13_hv_pmos L=0.6u W=6.66u
Mclamp_g2_r1 iovdd gate pad iovdd sg13_hv_pmos L=0.6u W=6.66u
Mclamp_g3_r0 pad gate iovdd iovdd sg13_hv_pmos L=0.6u W=6.66u
Mclamp_g3_r1 pad gate iovdd iovdd sg13_hv_pmos L=0.6u W=6.66u
Mclamp_g4_r0 iovdd gate pad iovdd sg13_hv_pmos L=0.6u W=6.66u
Mclamp_g4_r1 iovdd gate pad iovdd sg13_hv_pmos L=0.6u W=6.66u
Mclamp_g5_r0 pad gate iovdd iovdd sg13_hv_pmos L=0.6u W=6.66u
Mclamp_g5_r1 pad gate iovdd iovdd sg13_hv_pmos L=0.6u W=6.66u
Mclamp_g6_r0 iovdd gate pad iovdd sg13_hv_pmos L=0.6u W=6.66u
Mclamp_g6_r1 iovdd gate pad iovdd sg13_hv_pmos L=0.6u W=6.66u
Mclamp_g7_r0 pad gate iovdd iovdd sg13_hv_pmos L=0.6u W=6.66u
Mclamp_g7_r1 pad gate iovdd iovdd sg13_hv_pmos L=0.6u W=6.66u
Mclamp_g8_r0 iovdd gate pad iovdd sg13_hv_pmos L=0.6u W=6.66u
Mclamp_g8_r1 iovdd gate pad iovdd sg13_hv_pmos L=0.6u W=6.66u
Mclamp_g9_r0 pad gate iovdd iovdd sg13_hv_pmos L=0.6u W=6.66u
Mclamp_g9_r1 pad gate iovdd iovdd sg13_hv_pmos L=0.6u W=6.66u
Mclamp_g10_r0 iovdd gate pad iovdd sg13_hv_pmos L=0.6u W=6.66u
Mclamp_g10_r1 iovdd gate pad iovdd sg13_hv_pmos L=0.6u W=6.66u
Mclamp_g11_r0 pad gate iovdd iovdd sg13_hv_pmos L=0.6u W=6.66u
Mclamp_g11_r1 pad gate iovdd iovdd sg13_hv_pmos L=0.6u W=6.66u
Mclamp_g12_r0 iovdd gate pad iovdd sg13_hv_pmos L=0.6u W=6.66u
Mclamp_g12_r1 iovdd gate pad iovdd sg13_hv_pmos L=0.6u W=6.66u
Mclamp_g13_r0 pad gate iovdd iovdd sg13_hv_pmos L=0.6u W=6.66u
Mclamp_g13_r1 pad gate iovdd iovdd sg13_hv_pmos L=0.6u W=6.66u
Mclamp_g14_r0 iovdd gate pad iovdd sg13_hv_pmos L=0.6u W=6.66u
Mclamp_g14_r1 iovdd gate pad iovdd sg13_hv_pmos L=0.6u W=6.66u
XOuterRing vss sg13g2_GuardRing_P16000W3852HFF
XInnerRing iovdd sg13g2_GuardRing_N15280W3132HTF
DDGATE gate iovdd dpantenna A=0.6084p P=3.12u
.ends sg13g2_Clamp_P15N15D

* sg13g2_IOPadOut30mA
* FITS TO SCH .subckt sg13g2_IOPadOut30mA vss vdd iovss iovdd c2p pad
.subckt sg13g2_IOPadOut30mA c2p iovdd iovss pad vdd vss
Xnclamp vss iovdd pad ngate sg13g2_Clamp_N15N15D
Xpclamp vss iovdd pad pgate sg13g2_Clamp_P15N15D
Xdcndiode vss pad iovdd1 sg13g2_DCNDiode
Xdcpdiode pad iovdd vss sg13g2_DCPDiode
Xgatelu vdd vss iovdd c2p ngate pgate sg13g2_GateLevelUpInv
.ends sg13g2_IOPadOut30mA

* sg13g2_IOPadTriOut4mA
.subckt sg13g2_IOPadTriOut4mA vss vdd iovss iovdd c2p c2p_en pad
Xnclamp iovss iovdd pad ngate sg13g2_Clamp_N2N2D
Xpclamp iovss iovdd pad pgate sg13g2_Clamp_P2N2D
Xdcndiode iovss pad iovdd sg13g2_DCNDiode
Xdcpdiode pad iovdd iovss sg13g2_DCPDiode
Xgatedec vdd vss iovdd c2p c2p_en ngate pgate sg13g2_GateDecode
.ends sg13g2_IOPadTriOut4mA

* sg13g2_IOPadTriOut16mA
.subckt sg13g2_IOPadTriOut16mA vss vdd iovss iovdd c2p c2p_en pad
Xnclamp iovss iovdd pad ngate sg13g2_Clamp_N8N8D
Xpclamp iovss iovdd pad pgate sg13g2_Clamp_P8N8D
Xdcndiode iovss pad iovdd sg13g2_DCNDiode
Xdcpdiode pad iovdd iovss sg13g2_DCPDiode
Xgatedec vdd vss iovdd c2p c2p_en ngate pgate sg13g2_GateDecode
.ends sg13g2_IOPadTriOut16mA

* sg13g2_IOPadTriOut30mA
.subckt sg13g2_IOPadTriOut30mA vss vdd iovss iovdd c2p c2p_en pad
Xnclamp iovss iovdd pad ngate sg13g2_Clamp_N15N15D
Xpclamp iovss iovdd pad pgate sg13g2_Clamp_P15N15D
Xdcndiode iovss pad iovdd sg13g2_DCNDiode
Xdcpdiode pad iovdd iovss sg13g2_DCPDiode
Xgatedec vdd vss iovdd c2p c2p_en ngate pgate sg13g2_GateDecode
.ends sg13g2_IOPadTriOut30mA

* sg13g2_IOPadInOut4mA
.subckt sg13g2_IOPadInOut4mA vss vdd iovss iovdd p2c c2p c2p_en pad
Xnclamp iovss iovdd pad ngate sg13g2_Clamp_N2N2D
Xpclamp iovss iovdd pad pgate sg13g2_Clamp_P2N2D
Xdcndiode iovss pad iovdd sg13g2_DCNDiode
Xdcpdiode pad iovdd iovss sg13g2_DCPDiode
Xgatedec vdd vss iovdd c2p c2p_en ngate pgate sg13g2_GateDecode
Xleveldown vdd vss iovdd iovss pad p2c sg13g2_LevelDown
.ends sg13g2_IOPadInOut4mA

* sg13g2_IOPadInOut16mA
.subckt sg13g2_IOPadInOut16mA vss vdd iovss iovdd p2c c2p c2p_en pad
Xnclamp iovss iovdd pad ngate sg13g2_Clamp_N8N8D
Xpclamp iovss iovdd pad pgate sg13g2_Clamp_P8N8D
Xdcndiode iovss pad iovdd sg13g2_DCNDiode
Xdcpdiode pad iovdd iovss sg13g2_DCPDiode
Xgatedec vdd vss iovdd c2p c2p_en ngate pgate sg13g2_GateDecode
Xleveldown vdd vss iovdd iovss pad p2c sg13g2_LevelDown
.ends sg13g2_IOPadInOut16mA

* sg13g2_IOPadInOut30mA
* FITS TO SCH .subckt sg13g2_IOPadInOut30mA vss vdd iovss iovdd p2c c2p c2p_en pad
.subckt sg13g2_IOPadInOut30mA c2p c2p_en iovdd iovss p2c pad vdd vss
Xnclamp vss iovdd pad ngate sg13g2_Clamp_N15N15D
Xpclamp vss iovdd pad pgate sg13g2_Clamp_P15N15D
Xdcndiode vss pad iovdd1 sg13g2_DCNDiode
Xdcpdiode pad iovdd vss sg13g2_DCPDiode
Xgatedec vdd vss iovdd c2p c2p_en ngate pgate sg13g2_GateDecode
Xleveldown vdd vss iovdd vss pad p2c sg13g2_LevelDown
.ends sg13g2_IOPadInOut30mA

* sg13g2_IOPadIOVss
* FITS TO SCH .subckt sg13g2_IOPadIOVss vss vdd iovss iovdd
.subckt sg13g2_IOPadIOVss iovdd iovss vdd vss
Xdcndiode vss vss iovdd1 sg13g2_DCNDiode
Xdcpdiode vss iovdd vss sg13g2_DCPDiode
.ends sg13g2_IOPadIOVss

* sg13g2_IOPadIOVdd
* FITS TO SCH .subckt sg13g2_IOPadIOVdd vss vdd iovss iovdd
.subckt sg13g2_IOPadIOVdd iovdd iovss vdd vss
Xnclamp vss iovdd iovdd ngate sg13g2_Clamp_N43N43D4R
Xrcres iovdd res_cap vss sg13g2_RCClampResistor
Xrcinv iovdd vss res_cap ngate sg13g2_RCClampInverter
Xpad_guard vss sg13g2_GuardRing_N16000W6624HFF
.ends sg13g2_IOPadIOVdd

* sg13g2_Clamp_N20N0D
.subckt sg13g2_Clamp_N20N0D iovss iovdd pad
Mclamp_g0 iovss off pad iovss sg13_hv_nmos L=0.6u W=4.4u
Mclamp_g1 pad off iovss iovss sg13_hv_nmos L=0.6u W=4.4u
Mclamp_g2 iovss off pad iovss sg13_hv_nmos L=0.6u W=4.4u
Mclamp_g3 pad off iovss iovss sg13_hv_nmos L=0.6u W=4.4u
Mclamp_g4 iovss off pad iovss sg13_hv_nmos L=0.6u W=4.4u
Mclamp_g5 pad off iovss iovss sg13_hv_nmos L=0.6u W=4.4u
Mclamp_g6 iovss off pad iovss sg13_hv_nmos L=0.6u W=4.4u
Mclamp_g7 pad off iovss iovss sg13_hv_nmos L=0.6u W=4.4u
Mclamp_g8 iovss off pad iovss sg13_hv_nmos L=0.6u W=4.4u
Mclamp_g9 pad off iovss iovss sg13_hv_nmos L=0.6u W=4.4u
Mclamp_g10 iovss off pad iovss sg13_hv_nmos L=0.6u W=4.4u
Mclamp_g11 pad off iovss iovss sg13_hv_nmos L=0.6u W=4.4u
Mclamp_g12 iovss off pad iovss sg13_hv_nmos L=0.6u W=4.4u
Mclamp_g13 pad off iovss iovss sg13_hv_nmos L=0.6u W=4.4u
Mclamp_g14 iovss off pad iovss sg13_hv_nmos L=0.6u W=4.4u
Mclamp_g15 pad off iovss iovss sg13_hv_nmos L=0.6u W=4.4u
Mclamp_g16 iovss off pad iovss sg13_hv_nmos L=0.6u W=4.4u
Mclamp_g17 pad off iovss iovss sg13_hv_nmos L=0.6u W=4.4u
Mclamp_g18 iovss off pad iovss sg13_hv_nmos L=0.6u W=4.4u
Mclamp_g19 pad off iovss iovss sg13_hv_nmos L=0.6u W=4.4u
XOuterRing iovdd sg13g2_GuardRing_N16000W1980HFF
XInnerRing iovss sg13g2_GuardRing_P15280W1260HFF
RRoff iovss off iovss rppd l=3.54u w=0.5u
.ends sg13g2_Clamp_N20N0D

* sg13g2_Clamp_P20N0D
.subckt sg13g2_Clamp_P20N0D iovss iovdd pad
Mclamp_g0_r0 iovdd off pad iovdd sg13_hv_pmos L=0.6u W=6.66u
Mclamp_g0_r1 iovdd off pad iovdd sg13_hv_pmos L=0.6u W=6.66u
Mclamp_g1_r0 pad off iovdd iovdd sg13_hv_pmos L=0.6u W=6.66u
Mclamp_g1_r1 pad off iovdd iovdd sg13_hv_pmos L=0.6u W=6.66u
Mclamp_g2_r0 iovdd off pad iovdd sg13_hv_pmos L=0.6u W=6.66u
Mclamp_g2_r1 iovdd off pad iovdd sg13_hv_pmos L=0.6u W=6.66u
Mclamp_g3_r0 pad off iovdd iovdd sg13_hv_pmos L=0.6u W=6.66u
Mclamp_g3_r1 pad off iovdd iovdd sg13_hv_pmos L=0.6u W=6.66u
Mclamp_g4_r0 iovdd off pad iovdd sg13_hv_pmos L=0.6u W=6.66u
Mclamp_g4_r1 iovdd off pad iovdd sg13_hv_pmos L=0.6u W=6.66u
Mclamp_g5_r0 pad off iovdd iovdd sg13_hv_pmos L=0.6u W=6.66u
Mclamp_g5_r1 pad off iovdd iovdd sg13_hv_pmos L=0.6u W=6.66u
Mclamp_g6_r0 iovdd off pad iovdd sg13_hv_pmos L=0.6u W=6.66u
Mclamp_g6_r1 iovdd off pad iovdd sg13_hv_pmos L=0.6u W=6.66u
Mclamp_g7_r0 pad off iovdd iovdd sg13_hv_pmos L=0.6u W=6.66u
Mclamp_g7_r1 pad off iovdd iovdd sg13_hv_pmos L=0.6u W=6.66u
Mclamp_g8_r0 iovdd off pad iovdd sg13_hv_pmos L=0.6u W=6.66u
Mclamp_g8_r1 iovdd off pad iovdd sg13_hv_pmos L=0.6u W=6.66u
Mclamp_g9_r0 pad off iovdd iovdd sg13_hv_pmos L=0.6u W=6.66u
Mclamp_g9_r1 pad off iovdd iovdd sg13_hv_pmos L=0.6u W=6.66u
Mclamp_g10_r0 iovdd off pad iovdd sg13_hv_pmos L=0.6u W=6.66u
Mclamp_g10_r1 iovdd off pad iovdd sg13_hv_pmos L=0.6u W=6.66u
Mclamp_g11_r0 pad off iovdd iovdd sg13_hv_pmos L=0.6u W=6.66u
Mclamp_g11_r1 pad off iovdd iovdd sg13_hv_pmos L=0.6u W=6.66u
Mclamp_g12_r0 iovdd off pad iovdd sg13_hv_pmos L=0.6u W=6.66u
Mclamp_g12_r1 iovdd off pad iovdd sg13_hv_pmos L=0.6u W=6.66u
Mclamp_g13_r0 pad off iovdd iovdd sg13_hv_pmos L=0.6u W=6.66u
Mclamp_g13_r1 pad off iovdd iovdd sg13_hv_pmos L=0.6u W=6.66u
Mclamp_g14_r0 iovdd off pad iovdd sg13_hv_pmos L=0.6u W=6.66u
Mclamp_g14_r1 iovdd off pad iovdd sg13_hv_pmos L=0.6u W=6.66u
Mclamp_g15_r0 pad off iovdd iovdd sg13_hv_pmos L=0.6u W=6.66u
Mclamp_g15_r1 pad off iovdd iovdd sg13_hv_pmos L=0.6u W=6.66u
Mclamp_g16_r0 iovdd off pad iovdd sg13_hv_pmos L=0.6u W=6.66u
Mclamp_g16_r1 iovdd off pad iovdd sg13_hv_pmos L=0.6u W=6.66u
Mclamp_g17_r0 pad off iovdd iovdd sg13_hv_pmos L=0.6u W=6.66u
Mclamp_g17_r1 pad off iovdd iovdd sg13_hv_pmos L=0.6u W=6.66u
Mclamp_g18_r0 iovdd off pad iovdd sg13_hv_pmos L=0.6u W=6.66u
Mclamp_g18_r1 iovdd off pad iovdd sg13_hv_pmos L=0.6u W=6.66u
Mclamp_g19_r0 pad off iovdd iovdd sg13_hv_pmos L=0.6u W=6.66u
Mclamp_g19_r1 pad off iovdd iovdd sg13_hv_pmos L=0.6u W=6.66u
XOuterRing iovss sg13g2_GuardRing_P16000W3852HFF
XInnerRing iovdd sg13g2_GuardRing_N15280W3132HTF
RRoff iovdd off iovdd rppd l=12.9u w=0.5u
.ends sg13g2_Clamp_P20N0D

* sg13g2_IOPadAnalog
* FITS TO SCH .subckt sg13g2_IOPadAnalog vss vdd iovss iovdd pad padres
.subckt sg13g2_IOPadAnalog iovdd iovss pad padbare padres vdd vss
Xnclamp vss iovdd pad sg13g2_Clamp_N20N0D
Xpclamp vss iovdd pad sg13g2_Clamp_P20N0D
Xdcndiode vss pad iovdd1 sg13g2_DCNDiode
Xdcpdiode pad iovdd vss sg13g2_DCPDiode
Xsecondprot iovdd vss pad padres sg13g2_SecondaryProtection
.ends sg13g2_IOPadAnalog

* sg13g2_Gallery
.subckt sg13g2_Gallery vdd vss iovdd iopadin_pad iopadout4ma_pad iopadout16ma_pad iopadout30ma_pad iopadtriout4ma_pad iopadtriout16ma_pad iopadtriout30ma_pad iopadinout4ma_pad iopadinout16ma_pad iopadinout30ma_pad iopadin_p2c iopadinout4ma_p2c iopadinout16ma_p2c iopadinout30ma_p2c iopadout4ma_c2p iopadout16ma_c2p iopadout30ma_c2p iopadtriout4ma_c2p iopadtriout16ma_c2p iopadtriout30ma_c2p iopadinout4ma_c2p iopadinout16ma_c2p iopadinout30ma_c2p iopadtriout4ma_c2p_en iopadtriout16ma_c2p_en iopadtriout30ma_c2p_en iopadinout4ma_c2p_en iopadinout16ma_c2p_en iopadinout30ma_c2p_en ana_out ana_outres
Xcorner vss vdd vss iovdd sg13g2_Corner
Xfiller200 vss vdd vss iovdd sg13g2_Filler200
Xfiller400 vss vdd vss iovdd sg13g2_Filler400
Xfiller1000 vss vdd vss iovdd sg13g2_Filler1000
Xfiller2000 vss vdd vss iovdd sg13g2_Filler2000
Xfiller4000 vss vdd vss iovdd sg13g2_Filler4000
Xfiller10000 vss vdd vss iovdd sg13g2_Filler10000
Xiopadvss vss vdd vss iovdd sg13g2_IOPadVss
Xiopadvdd vss vdd vss iovdd sg13g2_IOPadVdd
Xiopadin vss vdd vss iovdd iopadin_p2c iopadin_pad sg13g2_IOPadIn
Xiopadout4ma vss vdd vss iovdd iopadout4ma_c2p iopadout4ma_pad sg13g2_IOPadOut4mA
Xiopadout16ma vss vdd vss iovdd iopadout16ma_c2p iopadout16ma_pad sg13g2_IOPadOut16mA
Xiopadout30ma vss vdd vss iovdd iopadout30ma_c2p iopadout30ma_pad sg13g2_IOPadOut30mA
Xiopadtriout4ma vss vdd vss iovdd iopadtriout4ma_c2p iopadtriout4ma_c2p_en iopadtriout4ma_pad sg13g2_IOPadTriOut4mA
Xiopadtriout16ma vss vdd vss iovdd iopadtriout16ma_c2p iopadtriout16ma_c2p_en iopadtriout16ma_pad sg13g2_IOPadTriOut16mA
Xiopadtriout30ma vss vdd vss iovdd iopadtriout30ma_c2p iopadtriout30ma_c2p_en iopadtriout30ma_pad sg13g2_IOPadTriOut30mA
Xiopadinout4ma vss vdd vss iovdd iopadinout4ma_p2c iopadinout4ma_c2p iopadinout4ma_c2p_en iopadinout4ma_pad sg13g2_IOPadInOut4mA
Xiopadinout16ma vss vdd vss iovdd iopadinout16ma_p2c iopadinout16ma_c2p iopadinout16ma_c2p_en iopadinout16ma_pad sg13g2_IOPadInOut16mA
Xiopadinout30ma vss vdd vss iovdd iopadinout30ma_p2c iopadinout30ma_c2p iopadinout30ma_c2p_en iopadinout30ma_pad sg13g2_IOPadInOut30mA
Xiopadiovss vss vdd vss iovdd sg13g2_IOPadIOVss
Xiopadiovdd vss vdd vss iovdd sg13g2_IOPadIOVdd
Xiopadanalog vss vdd vss iovdd ana_out ana_outres sg13g2_IOPadAnalog
Xcorner2 vss vdd vss iovdd sg13g2_Corner
.ends sg13g2_Gallery
