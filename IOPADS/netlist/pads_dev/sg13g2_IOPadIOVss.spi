* sg13g2_IOPadIOVss

* Split from sg13g2_io_devices.spi on 2026-08-03; contains sg13g2_IOPadIOVss and its
* 4 supporting subckts. Edit the source netlist, not this file.

* Autogenerated file; please don't edit
* date: 2024-05-27 14:30:57.050559

************************************************************************
*
* Copyright 2024 IHP PDK Authors
*
* Licensed under the Apache License, Version 2.0 (the "License");
* you may not use this file except in compliance with the License.
* You may obtain a copy of the License at
*
*    https://www.apache.org/licenses/LICENSE-2.0
*
* Unless required by applicable law or agreed to in writing, software
* distributed under the License is distributed on an "AS IS" BASIS,
* WITHOUT WARRANTIES OR CONDITIONS OF ANY KIND, either express or implied.
* See the License for the specific language governing permissions and
* limitations under the License.
*
************************************************************************

* sg13g2_GuardRing_N7276W2716HFF
.subckt sg13g2_GuardRing_N7276W2716HFF conn

.ends sg13g2_GuardRing_N7276W2716HFF

* sg13g2_DCNDiode
.subckt sg13g2_DCNDiode anode cathode guard
Ddcdiode_0 anode cathode dantenna A=35.0028p P=58.08u
Ddcdiode_1 anode cathode dantenna A=35.0028p P=58.08u
Xguard guard sg13g2_GuardRing_N7276W2716HFF
.ends sg13g2_DCNDiode

* sg13g2_GuardRing_P7276W2716HFF
.subckt sg13g2_GuardRing_P7276W2716HFF conn

.ends sg13g2_GuardRing_P7276W2716HFF

* sg13g2_DCPDiode
.subckt sg13g2_DCPDiode anode cathode guard
Ddcdiode_0 anode cathode dpantenna A=35.0028p P=58.08u
Ddcdiode_1 anode cathode dpantenna A=35.0028p P=58.08u
Xguard guard sg13g2_GuardRing_P7276W2716HFF
.ends sg13g2_DCPDiode

* sg13g2_IOPadIOVss
* FITS TO SCH .subckt sg13g2_IOPadIOVss vss vdd iovss iovdd
.subckt sg13g2_IOPadIOVss iovdd iovss vdd vss
Xdcndiode vss vss iovdd1 sg13g2_DCNDiode
Xdcpdiode vss iovdd vss sg13g2_DCPDiode
.ends sg13g2_IOPadIOVss
