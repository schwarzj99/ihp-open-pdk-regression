* sg13g2_IOPadInOut30mA

* Split from sg13g2_io_devices.spi on 2026-08-03; contains sg13g2_IOPadInOut30mA and its
* 21 supporting subckts. Edit the source netlist, not this file.

* Autogenerated file; please don't edit
* date: 2024-05-27 14:30:57.050559

************************************************************************
*
* Copyright 2024 IHP PDK Authors
*
* Licensed under the Apache License, Version 2.0 (the "License");
* you may not use this file except in compliance with the License.
* You may obtain a copy of the License at
*
*    https://www.apache.org/licenses/LICENSE-2.0
*
* Unless required by applicable law or agreed to in writing, software
* distributed under the License is distributed on an "AS IS" BASIS,
* WITHOUT WARRANTIES OR CONDITIONS OF ANY KIND, either express or implied.
* See the License for the specific language governing permissions and
* limitations under the License.
*
************************************************************************

* sg13g2_io_tie
.subckt sg13g2_io_tie vdd vss

.ends sg13g2_io_tie

* sg13g2_io_inv_x1
.subckt sg13g2_io_inv_x1 vdd vss i nq
Mnmos vss i nq vss sg13_lv_nmos L=0.13u W=3.93u
Mpmos vdd i nq vdd sg13_lv_pmos L=0.13u W=4.41u
.ends sg13g2_io_inv_x1

* sg13g2_io_nor2_x1
.subckt sg13g2_io_nor2_x1 vdd vss nq i0 i1
Mi0_nmos vss i0 nq vss sg13_lv_nmos L=0.13u W=3.93u
Mi0_pmos vdd i0 _net0 vdd sg13_lv_pmos L=0.13u W=4.41u
Mi1_nmos nq i1 vss vss sg13_lv_nmos L=0.13u W=3.93u
Mi1_pmos _net0 i1 nq vdd sg13_lv_pmos L=0.13u W=4.41u
.ends sg13g2_io_nor2_x1

* sg13g2_LevelUp
.subckt sg13g2_LevelUp vdd iovdd vss i o
Mn_i_inv i_n i vss vss sg13_lv_nmos L=0.13u W=2.75u
Mp_i_inv i_n i vdd vdd sg13_lv_pmos L=0.13u W=4.75u
Mn_lvld_n vss i lvld_n vss sg13_hv_nmos L=0.45u W=1.9u
Mn_lvld lvld i_n vss vss sg13_hv_nmos L=0.45u W=1.9u
Mp_lvld_n iovdd lvld lvld_n iovdd sg13_hv_pmos L=0.45u W=0.3u
Mp_lvld lvld lvld_n iovdd iovdd sg13_hv_pmos L=0.45u W=0.3u
Mn_lvld_n_inv vss lvld_n o vss sg13_hv_nmos L=0.45u W=1.9u
Mp_lvld_n_inv iovdd lvld_n o iovdd sg13_hv_pmos L=0.45u W=3.9u
.ends sg13g2_LevelUp

* sg13g2_io_nand2_x1
.subckt sg13g2_io_nand2_x1 vdd vss nq i0 i1
Mi0_nmos vss i0 _net0 vss sg13_lv_nmos L=0.13u W=3.93u
Mi0_pmos vdd i0 nq vdd sg13_lv_pmos L=0.13u W=4.41u
Mi1_nmos _net0 i1 nq vss sg13_lv_nmos L=0.13u W=3.93u
Mi1_pmos nq i1 vdd vdd sg13_lv_pmos L=0.13u W=4.41u
.ends sg13g2_io_nand2_x1

* sg13g2_GateDecode
.subckt sg13g2_GateDecode vdd vss iovdd core en ngate pgate
Xtieinst vdd vss sg13g2_io_tie
Xen_inv vdd vss en en_n sg13g2_io_inv_x1
Xngate_nor vdd vss ngate_core core en_n sg13g2_io_nor2_x1
Xngate_levelup vdd iovdd vss ngate_core ngate sg13g2_LevelUp
Xpgate_nand vdd vss pgate_core core en sg13g2_io_nand2_x1
Xpgate_levelup vdd iovdd vss pgate_core pgate sg13g2_LevelUp
.ends sg13g2_GateDecode

* sg13g2_GuardRing_P576W948HFF
.subckt sg13g2_GuardRing_P576W948HFF conn

.ends sg13g2_GuardRing_P576W948HFF

* sg13g2_GuardRing_P456W948HFF
.subckt sg13g2_GuardRing_P456W948HFF conn

.ends sg13g2_GuardRing_P456W948HFF

* sg13g2_GuardRing_N1324W456HTF
.subckt sg13g2_GuardRing_N1324W456HTF conn

.ends sg13g2_GuardRing_N1324W456HTF

* sg13g2_SecondaryProtection
.subckt sg13g2_SecondaryProtection iovdd iovss pad core
RR pad core iovss rppd l=2u w=1u
Xguard1 iovss sg13g2_GuardRing_P576W948HFF
DDN iovss core dantenna A=1.984p P=7.48u
Xguard2 iovss sg13g2_GuardRing_P456W948HFF
DDP core iovdd dpantenna A=3.1872p P=11.24u
Xguard3 iovdd sg13g2_GuardRing_N1324W456HTF
.ends sg13g2_SecondaryProtection

* sg13g2_LevelDown
.subckt sg13g2_LevelDown vdd vss iovdd iovss pad core
Mn_hvinv vss padres padres_n vss sg13_hv_nmos L=0.45u W=2.65u
Mp_hvinv vdd padres padres_n vdd sg13_hv_pmos L=0.45u W=4.65u
Mn_lvinv core padres_n vss vss sg13_lv_nmos L=0.13u W=2.75u
Mp_lvinv core padres_n vdd vdd sg13_lv_pmos L=0.13u W=4.75u
Xsecondprot iovdd vss pad padres sg13g2_SecondaryProtection
.ends sg13g2_LevelDown

* sg13g2_GuardRing_N7276W2716HFF
.subckt sg13g2_GuardRing_N7276W2716HFF conn

.ends sg13g2_GuardRing_N7276W2716HFF

* sg13g2_DCNDiode
.subckt sg13g2_DCNDiode anode cathode guard
Ddcdiode_0 anode cathode dantenna A=35.0028p P=58.08u
Ddcdiode_1 anode cathode dantenna A=35.0028p P=58.08u
Xguard guard sg13g2_GuardRing_N7276W2716HFF
.ends sg13g2_DCNDiode

* sg13g2_GuardRing_P7276W2716HFF
.subckt sg13g2_GuardRing_P7276W2716HFF conn

.ends sg13g2_GuardRing_P7276W2716HFF

* sg13g2_DCPDiode
.subckt sg13g2_DCPDiode anode cathode guard
Ddcdiode_0 anode cathode dpantenna A=35.0028p P=58.08u
Ddcdiode_1 anode cathode dpantenna A=35.0028p P=58.08u
Xguard guard sg13g2_GuardRing_P7276W2716HFF
.ends sg13g2_DCPDiode

* sg13g2_GuardRing_N16000W1980HFF
.subckt sg13g2_GuardRing_N16000W1980HFF conn

.ends sg13g2_GuardRing_N16000W1980HFF

* sg13g2_GuardRing_P15280W1260HFF
.subckt sg13g2_GuardRing_P15280W1260HFF conn

.ends sg13g2_GuardRing_P15280W1260HFF

* sg13g2_GuardRing_P16000W3852HFF
.subckt sg13g2_GuardRing_P16000W3852HFF conn

.ends sg13g2_GuardRing_P16000W3852HFF

* sg13g2_GuardRing_N15280W3132HTF
.subckt sg13g2_GuardRing_N15280W3132HTF conn

.ends sg13g2_GuardRing_N15280W3132HTF

* sg13g2_Clamp_N15N15D
.subckt sg13g2_Clamp_N15N15D iovss iovdd pad gate
Mclamp_g0 iovss gate pad iovss sg13_hv_nmos L=0.6u W=4.4u
Mclamp_g1 pad gate iovss iovss sg13_hv_nmos L=0.6u W=4.4u
Mclamp_g2 iovss gate pad iovss sg13_hv_nmos L=0.6u W=4.4u
Mclamp_g3 pad gate iovss iovss sg13_hv_nmos L=0.6u W=4.4u
Mclamp_g4 iovss gate pad iovss sg13_hv_nmos L=0.6u W=4.4u
Mclamp_g5 pad gate iovss iovss sg13_hv_nmos L=0.6u W=4.4u
Mclamp_g6 iovss gate pad iovss sg13_hv_nmos L=0.6u W=4.4u
Mclamp_g7 pad gate iovss iovss sg13_hv_nmos L=0.6u W=4.4u
Mclamp_g8 iovss gate pad iovss sg13_hv_nmos L=0.6u W=4.4u
Mclamp_g9 pad gate iovss iovss sg13_hv_nmos L=0.6u W=4.4u
Mclamp_g10 iovss gate pad iovss sg13_hv_nmos L=0.6u W=4.4u
Mclamp_g11 pad gate iovss iovss sg13_hv_nmos L=0.6u W=4.4u
Mclamp_g12 iovss gate pad iovss sg13_hv_nmos L=0.6u W=4.4u
Mclamp_g13 pad gate iovss iovss sg13_hv_nmos L=0.6u W=4.4u
Mclamp_g14 iovss gate pad iovss sg13_hv_nmos L=0.6u W=4.4u
XOuterRing iovdd sg13g2_GuardRing_N16000W1980HFF
XInnerRing iovss sg13g2_GuardRing_P15280W1260HFF
DDGATE iovss gate dantenna A=0.6084p P=3.12u
.ends sg13g2_Clamp_N15N15D

* sg13g2_Clamp_P15N15D
.subckt sg13g2_Clamp_P15N15D iovss iovdd pad gate
Mclamp_g0_r0 iovdd gate pad iovdd sg13_hv_pmos L=0.6u W=6.66u
Mclamp_g0_r1 iovdd gate pad iovdd sg13_hv_pmos L=0.6u W=6.66u
Mclamp_g1_r0 pad gate iovdd iovdd sg13_hv_pmos L=0.6u W=6.66u
Mclamp_g1_r1 pad gate iovdd iovdd sg13_hv_pmos L=0.6u W=6.66u
Mclamp_g2_r0 iovdd gate pad iovdd sg13_hv_pmos L=0.6u W=6.66u
Mclamp_g2_r1 iovdd gate pad iovdd sg13_hv_pmos L=0.6u W=6.66u
Mclamp_g3_r0 pad gate iovdd iovdd sg13_hv_pmos L=0.6u W=6.66u
Mclamp_g3_r1 pad gate iovdd iovdd sg13_hv_pmos L=0.6u W=6.66u
Mclamp_g4_r0 iovdd gate pad iovdd sg13_hv_pmos L=0.6u W=6.66u
Mclamp_g4_r1 iovdd gate pad iovdd sg13_hv_pmos L=0.6u W=6.66u
Mclamp_g5_r0 pad gate iovdd iovdd sg13_hv_pmos L=0.6u W=6.66u
Mclamp_g5_r1 pad gate iovdd iovdd sg13_hv_pmos L=0.6u W=6.66u
Mclamp_g6_r0 iovdd gate pad iovdd sg13_hv_pmos L=0.6u W=6.66u
Mclamp_g6_r1 iovdd gate pad iovdd sg13_hv_pmos L=0.6u W=6.66u
Mclamp_g7_r0 pad gate iovdd iovdd sg13_hv_pmos L=0.6u W=6.66u
Mclamp_g7_r1 pad gate iovdd iovdd sg13_hv_pmos L=0.6u W=6.66u
Mclamp_g8_r0 iovdd gate pad iovdd sg13_hv_pmos L=0.6u W=6.66u
Mclamp_g8_r1 iovdd gate pad iovdd sg13_hv_pmos L=0.6u W=6.66u
Mclamp_g9_r0 pad gate iovdd iovdd sg13_hv_pmos L=0.6u W=6.66u
Mclamp_g9_r1 pad gate iovdd iovdd sg13_hv_pmos L=0.6u W=6.66u
Mclamp_g10_r0 iovdd gate pad iovdd sg13_hv_pmos L=0.6u W=6.66u
Mclamp_g10_r1 iovdd gate pad iovdd sg13_hv_pmos L=0.6u W=6.66u
Mclamp_g11_r0 pad gate iovdd iovdd sg13_hv_pmos L=0.6u W=6.66u
Mclamp_g11_r1 pad gate iovdd iovdd sg13_hv_pmos L=0.6u W=6.66u
Mclamp_g12_r0 iovdd gate pad iovdd sg13_hv_pmos L=0.6u W=6.66u
Mclamp_g12_r1 iovdd gate pad iovdd sg13_hv_pmos L=0.6u W=6.66u
Mclamp_g13_r0 pad gate iovdd iovdd sg13_hv_pmos L=0.6u W=6.66u
Mclamp_g13_r1 pad gate iovdd iovdd sg13_hv_pmos L=0.6u W=6.66u
Mclamp_g14_r0 iovdd gate pad iovdd sg13_hv_pmos L=0.6u W=6.66u
Mclamp_g14_r1 iovdd gate pad iovdd sg13_hv_pmos L=0.6u W=6.66u
XOuterRing vss sg13g2_GuardRing_P16000W3852HFF
XInnerRing iovdd sg13g2_GuardRing_N15280W3132HTF
DDGATE gate iovdd dpantenna A=0.6084p P=3.12u
.ends sg13g2_Clamp_P15N15D

* sg13g2_IOPadInOut30mA
* FITS TO SCH .subckt sg13g2_IOPadInOut30mA vss vdd iovss iovdd p2c c2p c2p_en pad
.subckt sg13g2_IOPadInOut30mA c2p c2p_en iovdd iovss p2c pad vdd vss
Xnclamp vss iovdd pad ngate sg13g2_Clamp_N15N15D
Xpclamp vss iovdd pad pgate sg13g2_Clamp_P15N15D
Xdcndiode vss pad iovdd1 sg13g2_DCNDiode
Xdcpdiode pad iovdd vss sg13g2_DCPDiode
Xgatedec vdd vss iovdd c2p c2p_en ngate pgate sg13g2_GateDecode
Xleveldown vdd vss iovdd vss pad p2c sg13g2_LevelDown
.ends sg13g2_IOPadInOut30mA
