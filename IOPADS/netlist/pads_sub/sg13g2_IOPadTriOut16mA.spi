* sg13g2_IOPadTriOut16mA

* Split from sg13g2_io_sub.spi on 2026-08-11; contains sg13g2_IOPadTriOut16mA and its
* 16 supporting subckts. Edit the source netlist, not this file.

* Autogenerated file; please don't edit
* date: 2024-05-27 14:30:57.050559

************************************************************************
*
* Copyright 2024 IHP PDK Authors
*
* Licensed under the Apache License, Version 2.0 (the "License");
* you may not use this file except in compliance with the License.
* You may obtain a copy of the License at
*
*    https://www.apache.org/licenses/LICENSE-2.0
*
* Unless required by applicable law or agreed to in writing, software
* distributed under the License is distributed on an "AS IS" BASIS,
* WITHOUT WARRANTIES OR CONDITIONS OF ANY KIND, either express or implied.
* See the License for the specific language governing permissions and
* limitations under the License.
*
************************************************************************

* sg13g2_io_tie
.GLOBAL sub

.subckt sg13g2_io_tie vdd vss

Rtap0 vss sub ptap1 A=0.6255p P=4.77u
.ends sg13g2_io_tie

* sg13g2_io_inv_x1
.subckt sg13g2_io_inv_x1 vdd vss i nq
Mnmos vss i nq sub sg13_lv_nmos L=0.13u W=3.93u
Mpmos vdd i nq vdd sg13_lv_pmos L=0.13u W=4.41u
Rtap0 vss sub ptap1 A=0.624p P=4.76u
.ends sg13g2_io_inv_x1

* sg13g2_io_nor2_x1
.subckt sg13g2_io_nor2_x1 vdd vss nq i0 i1
Mi0_nmos vss i0 nq sub sg13_lv_nmos L=0.13u W=3.93u
Mi0_pmos vdd i0 _net0 vdd sg13_lv_pmos L=0.13u W=4.41u
Mi1_nmos nq i1 vss sub sg13_lv_nmos L=0.13u W=3.93u
Mi1_pmos _net0 i1 nq vdd sg13_lv_pmos L=0.13u W=4.41u
Rtap0 vss sub ptap1 A=0.657p P=4.98u
.ends sg13g2_io_nor2_x1

* sg13g2_LevelUp
.subckt sg13g2_LevelUp vdd iovdd vss i o
Mn_i_inv i_n i vss sub sg13_lv_nmos L=0.13u W=2.75u
Mp_i_inv i_n i vdd vdd sg13_lv_pmos L=0.13u W=4.75u
Mn_lvld_n vss i lvld_n sub sg13_hv_nmos L=0.45u W=1.9u
Mn_lvld lvld i_n vss sub sg13_hv_nmos L=0.45u W=1.9u
Mp_lvld_n iovdd lvld lvld_n iovdd sg13_hv_pmos L=0.45u W=0.3u
Mp_lvld lvld lvld_n iovdd iovdd sg13_hv_pmos L=0.45u W=0.3u
Mn_lvld_n_inv vss lvld_n o sub sg13_hv_nmos L=0.45u W=1.9u
Mp_lvld_n_inv iovdd lvld_n o iovdd sg13_hv_pmos L=0.45u W=3.9u
Rtap0 vss sub ptap1 A=0.9135p P=6.69u
.ends sg13g2_LevelUp

* sg13g2_io_nand2_x1
.subckt sg13g2_io_nand2_x1 vdd vss nq i0 i1
Mi0_nmos vss i0 _net0 sub sg13_lv_nmos L=0.13u W=3.93u
Mi0_pmos vdd i0 nq vdd sg13_lv_pmos L=0.13u W=4.41u
Mi1_nmos _net0 i1 nq sub sg13_lv_nmos L=0.13u W=3.93u
Mi1_pmos nq i1 vdd vdd sg13_lv_pmos L=0.13u W=4.41u
Rtap0 vss sub ptap1 A=0.657p P=4.98u
.ends sg13g2_io_nand2_x1

* sg13g2_GateDecode
.subckt sg13g2_GateDecode vdd vss iovdd core en ngate pgate
Xtieinst vdd vss sg13g2_io_tie
Xen_inv vdd vss en en_n sg13g2_io_inv_x1
Xngate_nor vdd vss ngate_core core en_n sg13g2_io_nor2_x1
Xngate_levelup vdd iovdd vss ngate_core ngate sg13g2_LevelUp
Xpgate_nand vdd vss pgate_core core en sg13g2_io_nand2_x1
Xpgate_levelup vdd iovdd vss pgate_core pgate sg13g2_LevelUp
.ends sg13g2_GateDecode

* sg13g2_GuardRing_N7276W2716HFF
.subckt sg13g2_GuardRing_N7276W2716HFF conn

.ends sg13g2_GuardRing_N7276W2716HFF

* sg13g2_DCNDiode
.subckt sg13g2_DCNDiode anode cathode guard
Ddcdiode_0 anode cathode dantenna A=35.0028p P=58.08u
Ddcdiode_1 anode cathode dantenna A=35.0028p P=58.08u
Xguard guard sg13g2_GuardRing_N7276W2716HFF
Rtap0 guard anode ptap1 A=141.2964p P=221.76u
.ends sg13g2_DCNDiode

* sg13g2_GuardRing_P7276W2716HFF
.subckt sg13g2_GuardRing_P7276W2716HFF conn

.ends sg13g2_GuardRing_P7276W2716HFF

* sg13g2_DCPDiode
.subckt sg13g2_DCPDiode anode cathode guard
Ddcdiode_0 anode cathode dpantenna A=35.0028p P=58.08u
Ddcdiode_1 anode cathode dpantenna A=35.0028p P=58.08u
Xguard guard sg13g2_GuardRing_P7276W2716HFF
Rtap0 guard sub ptap1 A=33.5104p P=197.12u
.ends sg13g2_DCPDiode

* sg13g2_GuardRing_N16000W1980HFF
.subckt sg13g2_GuardRing_N16000W1980HFF conn

.ends sg13g2_GuardRing_N16000W1980HFF

* sg13g2_GuardRing_P15280W1260HFF
.subckt sg13g2_GuardRing_P15280W1260HFF conn

.ends sg13g2_GuardRing_P15280W1260HFF

* sg13g2_GuardRing_P16000W3852HFF
.subckt sg13g2_GuardRing_P16000W3852HFF conn

.ends sg13g2_GuardRing_P16000W3852HFF

* sg13g2_GuardRing_N15280W3132HTF
.subckt sg13g2_GuardRing_N15280W3132HTF conn

.ends sg13g2_GuardRing_N15280W3132HTF

* sg13g2_Clamp_N8N8D
.subckt sg13g2_Clamp_N8N8D iovss iovdd pad gate
Mclamp_g0 iovss gate pad sub sg13_hv_nmos L=0.6u W=4.4u
Mclamp_g1 pad gate iovss sub sg13_hv_nmos L=0.6u W=4.4u
Mclamp_g2 iovss gate pad sub sg13_hv_nmos L=0.6u W=4.4u
Mclamp_g3 pad gate iovss sub sg13_hv_nmos L=0.6u W=4.4u
Mclamp_g4 iovss gate pad sub sg13_hv_nmos L=0.6u W=4.4u
Mclamp_g5 pad gate iovss sub sg13_hv_nmos L=0.6u W=4.4u
Mclamp_g6 iovss gate pad sub sg13_hv_nmos L=0.6u W=4.4u
Mclamp_g7 pad gate iovss sub sg13_hv_nmos L=0.6u W=4.4u
XOuterRing iovdd sg13g2_GuardRing_N16000W1980HFF
XInnerRing iovss sg13g2_GuardRing_P15280W1260HFF
DDGATE sub gate dantenna A=0.6084p P=3.12u
Rtap0 iovss sub ptap1 A=55.7736p P=328.08u
.ends sg13g2_Clamp_N8N8D

* sg13g2_Clamp_P8N8D
.subckt sg13g2_Clamp_P8N8D iovss iovdd pad gate
Mclamp_g0_r0 iovdd gate pad iovdd sg13_hv_pmos L=0.6u W=6.66u
Mclamp_g0_r1 iovdd gate pad iovdd sg13_hv_pmos L=0.6u W=6.66u
Mclamp_g1_r0 pad gate iovdd iovdd sg13_hv_pmos L=0.6u W=6.66u
Mclamp_g1_r1 pad gate iovdd iovdd sg13_hv_pmos L=0.6u W=6.66u
Mclamp_g2_r0 iovdd gate pad iovdd sg13_hv_pmos L=0.6u W=6.66u
Mclamp_g2_r1 iovdd gate pad iovdd sg13_hv_pmos L=0.6u W=6.66u
Mclamp_g3_r0 pad gate iovdd iovdd sg13_hv_pmos L=0.6u W=6.66u
Mclamp_g3_r1 pad gate iovdd iovdd sg13_hv_pmos L=0.6u W=6.66u
Mclamp_g4_r0 iovdd gate pad iovdd sg13_hv_pmos L=0.6u W=6.66u
Mclamp_g4_r1 iovdd gate pad iovdd sg13_hv_pmos L=0.6u W=6.66u
Mclamp_g5_r0 pad gate iovdd iovdd sg13_hv_pmos L=0.6u W=6.66u
Mclamp_g5_r1 pad gate iovdd iovdd sg13_hv_pmos L=0.6u W=6.66u
Mclamp_g6_r0 iovdd gate pad iovdd sg13_hv_pmos L=0.6u W=6.66u
Mclamp_g6_r1 iovdd gate pad iovdd sg13_hv_pmos L=0.6u W=6.66u
Mclamp_g7_r0 pad gate iovdd iovdd sg13_hv_pmos L=0.6u W=6.66u
Mclamp_g7_r1 pad gate iovdd iovdd sg13_hv_pmos L=0.6u W=6.66u
XOuterRing iovss sg13g2_GuardRing_P16000W3852HFF
XInnerRing iovdd sg13g2_GuardRing_N15280W3132HTF
DDGATE gate iovdd dpantenna A=0.2304p P=1.92u
Rtap0 iovss sub ptap1 A=67.0344p P=394.32u
.ends sg13g2_Clamp_P8N8D

* sg13g2_IOPadTriOut16mA
.subckt sg13g2_IOPadTriOut16mA vss vdd iovss iovdd c2p c2p_en pad
Xnclamp iovss iovdd pad ngate sg13g2_Clamp_N8N8D
Xpclamp iovss iovdd pad pgate sg13g2_Clamp_P8N8D
Xdcndiode sub pad iovss sg13g2_DCNDiode
Xdcpdiode pad iovdd iovss sg13g2_DCPDiode
Xgatedec vdd vss iovdd c2p c2p_en ngate pgate sg13g2_GateDecode
Rtap0 iovss sub ptap1 A=4313.4p P=594.62u
Rtap1 vss sub ptap1 A=24p P=160.6u
.ends sg13g2_IOPadTriOut16mA
