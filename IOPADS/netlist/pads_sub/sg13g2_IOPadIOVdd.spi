* sg13g2_IOPadIOVdd

* Split from sg13g2_io_sub.spi on 2026-08-11; contains sg13g2_IOPadIOVdd and its
* 8 supporting subckts. Edit the source netlist, not this file.

* Autogenerated file; please don't edit
* date: 2024-05-27 14:30:57.050559

************************************************************************
*
* Copyright 2024 IHP PDK Authors
*
* Licensed under the Apache License, Version 2.0 (the "License");
* you may not use this file except in compliance with the License.
* You may obtain a copy of the License at
*
*    https://www.apache.org/licenses/LICENSE-2.0
*
* Unless required by applicable law or agreed to in writing, software
* distributed under the License is distributed on an "AS IS" BASIS,
* WITHOUT WARRANTIES OR CONDITIONS OF ANY KIND, either express or implied.
* See the License for the specific language governing permissions and
* limitations under the License.
*
************************************************************************

* sg13g2_io_tie
.GLOBAL sub

* sg13g2_GuardRing_N16000W4884HFF
.subckt sg13g2_GuardRing_N16000W4884HFF conn

.ends sg13g2_GuardRing_N16000W4884HFF

* sg13g2_GuardRing_P15280W4164HFF
.subckt sg13g2_GuardRing_P15280W4164HFF conn

.ends sg13g2_GuardRing_P15280W4164HFF

* sg13g2_Clamp_N43N43D4R
.subckt sg13g2_Clamp_N43N43D4R iovss iovdd pad gate
Mclamp_g0_r0 iovss gate pad sub sg13_hv_nmos L=0.6u W=4.4u
Mclamp_g0_r1 iovss gate pad sub sg13_hv_nmos L=0.6u W=4.4u
Mclamp_g0_r2 iovss gate pad sub sg13_hv_nmos L=0.6u W=4.4u
Mclamp_g0_r3 iovss gate pad sub sg13_hv_nmos L=0.6u W=4.4u
Mclamp_g1_r0 pad gate iovss sub sg13_hv_nmos L=0.6u W=4.4u
Mclamp_g1_r1 pad gate iovss sub sg13_hv_nmos L=0.6u W=4.4u
Mclamp_g1_r2 pad gate iovss sub sg13_hv_nmos L=0.6u W=4.4u
Mclamp_g1_r3 pad gate iovss sub sg13_hv_nmos L=0.6u W=4.4u
Mclamp_g2_r0 iovss gate pad sub sg13_hv_nmos L=0.6u W=4.4u
Mclamp_g2_r1 iovss gate pad sub sg13_hv_nmos L=0.6u W=4.4u
Mclamp_g2_r2 iovss gate pad sub sg13_hv_nmos L=0.6u W=4.4u
Mclamp_g2_r3 iovss gate pad sub sg13_hv_nmos L=0.6u W=4.4u
Mclamp_g3_r0 pad gate iovss sub sg13_hv_nmos L=0.6u W=4.4u
Mclamp_g3_r1 pad gate iovss sub sg13_hv_nmos L=0.6u W=4.4u
Mclamp_g3_r2 pad gate iovss sub sg13_hv_nmos L=0.6u W=4.4u
Mclamp_g3_r3 pad gate iovss sub sg13_hv_nmos L=0.6u W=4.4u
Mclamp_g4_r0 iovss gate pad sub sg13_hv_nmos L=0.6u W=4.4u
Mclamp_g4_r1 iovss gate pad sub sg13_hv_nmos L=0.6u W=4.4u
Mclamp_g4_r2 iovss gate pad sub sg13_hv_nmos L=0.6u W=4.4u
Mclamp_g4_r3 iovss gate pad sub sg13_hv_nmos L=0.6u W=4.4u
Mclamp_g5_r0 pad gate iovss sub sg13_hv_nmos L=0.6u W=4.4u
Mclamp_g5_r1 pad gate iovss sub sg13_hv_nmos L=0.6u W=4.4u
Mclamp_g5_r2 pad gate iovss sub sg13_hv_nmos L=0.6u W=4.4u
Mclamp_g5_r3 pad gate iovss sub sg13_hv_nmos L=0.6u W=4.4u
Mclamp_g6_r0 iovss gate pad sub sg13_hv_nmos L=0.6u W=4.4u
Mclamp_g6_r1 iovss gate pad sub sg13_hv_nmos L=0.6u W=4.4u
Mclamp_g6_r2 iovss gate pad sub sg13_hv_nmos L=0.6u W=4.4u
Mclamp_g6_r3 iovss gate pad sub sg13_hv_nmos L=0.6u W=4.4u
Mclamp_g7_r0 pad gate iovss sub sg13_hv_nmos L=0.6u W=4.4u
Mclamp_g7_r1 pad gate iovss sub sg13_hv_nmos L=0.6u W=4.4u
Mclamp_g7_r2 pad gate iovss sub sg13_hv_nmos L=0.6u W=4.4u
Mclamp_g7_r3 pad gate iovss sub sg13_hv_nmos L=0.6u W=4.4u
Mclamp_g8_r0 iovss gate pad sub sg13_hv_nmos L=0.6u W=4.4u
Mclamp_g8_r1 iovss gate pad sub sg13_hv_nmos L=0.6u W=4.4u
Mclamp_g8_r2 iovss gate pad sub sg13_hv_nmos L=0.6u W=4.4u
Mclamp_g8_r3 iovss gate pad sub sg13_hv_nmos L=0.6u W=4.4u
Mclamp_g9_r0 pad gate iovss sub sg13_hv_nmos L=0.6u W=4.4u
Mclamp_g9_r1 pad gate iovss sub sg13_hv_nmos L=0.6u W=4.4u
Mclamp_g9_r2 pad gate iovss sub sg13_hv_nmos L=0.6u W=4.4u
Mclamp_g9_r3 pad gate iovss sub sg13_hv_nmos L=0.6u W=4.4u
Mclamp_g10_r0 iovss gate pad sub sg13_hv_nmos L=0.6u W=4.4u
Mclamp_g10_r1 iovss gate pad sub sg13_hv_nmos L=0.6u W=4.4u
Mclamp_g10_r2 iovss gate pad sub sg13_hv_nmos L=0.6u W=4.4u
Mclamp_g10_r3 iovss gate pad sub sg13_hv_nmos L=0.6u W=4.4u
Mclamp_g11_r0 pad gate iovss sub sg13_hv_nmos L=0.6u W=4.4u
Mclamp_g11_r1 pad gate iovss sub sg13_hv_nmos L=0.6u W=4.4u
Mclamp_g11_r2 pad gate iovss sub sg13_hv_nmos L=0.6u W=4.4u
Mclamp_g11_r3 pad gate iovss sub sg13_hv_nmos L=0.6u W=4.4u
Mclamp_g12_r0 iovss gate pad sub sg13_hv_nmos L=0.6u W=4.4u
Mclamp_g12_r1 iovss gate pad sub sg13_hv_nmos L=0.6u W=4.4u
Mclamp_g12_r2 iovss gate pad sub sg13_hv_nmos L=0.6u W=4.4u
Mclamp_g12_r3 iovss gate pad sub sg13_hv_nmos L=0.6u W=4.4u
Mclamp_g13_r0 pad gate iovss sub sg13_hv_nmos L=0.6u W=4.4u
Mclamp_g13_r1 pad gate iovss sub sg13_hv_nmos L=0.6u W=4.4u
Mclamp_g13_r2 pad gate iovss sub sg13_hv_nmos L=0.6u W=4.4u
Mclamp_g13_r3 pad gate iovss sub sg13_hv_nmos L=0.6u W=4.4u
Mclamp_g14_r0 iovss gate pad sub sg13_hv_nmos L=0.6u W=4.4u
Mclamp_g14_r1 iovss gate pad sub sg13_hv_nmos L=0.6u W=4.4u
Mclamp_g14_r2 iovss gate pad sub sg13_hv_nmos L=0.6u W=4.4u
Mclamp_g14_r3 iovss gate pad sub sg13_hv_nmos L=0.6u W=4.4u
Mclamp_g15_r0 pad gate iovss sub sg13_hv_nmos L=0.6u W=4.4u
Mclamp_g15_r1 pad gate iovss sub sg13_hv_nmos L=0.6u W=4.4u
Mclamp_g15_r2 pad gate iovss sub sg13_hv_nmos L=0.6u W=4.4u
Mclamp_g15_r3 pad gate iovss sub sg13_hv_nmos L=0.6u W=4.4u
Mclamp_g16_r0 iovss gate pad sub sg13_hv_nmos L=0.6u W=4.4u
Mclamp_g16_r1 iovss gate pad sub sg13_hv_nmos L=0.6u W=4.4u
Mclamp_g16_r2 iovss gate pad sub sg13_hv_nmos L=0.6u W=4.4u
Mclamp_g16_r3 iovss gate pad sub sg13_hv_nmos L=0.6u W=4.4u
Mclamp_g17_r0 pad gate iovss sub sg13_hv_nmos L=0.6u W=4.4u
Mclamp_g17_r1 pad gate iovss sub sg13_hv_nmos L=0.6u W=4.4u
Mclamp_g17_r2 pad gate iovss sub sg13_hv_nmos L=0.6u W=4.4u
Mclamp_g17_r3 pad gate iovss sub sg13_hv_nmos L=0.6u W=4.4u
Mclamp_g18_r0 iovss gate pad sub sg13_hv_nmos L=0.6u W=4.4u
Mclamp_g18_r1 iovss gate pad sub sg13_hv_nmos L=0.6u W=4.4u
Mclamp_g18_r2 iovss gate pad sub sg13_hv_nmos L=0.6u W=4.4u
Mclamp_g18_r3 iovss gate pad sub sg13_hv_nmos L=0.6u W=4.4u
Mclamp_g19_r0 pad gate iovss sub sg13_hv_nmos L=0.6u W=4.4u
Mclamp_g19_r1 pad gate iovss sub sg13_hv_nmos L=0.6u W=4.4u
Mclamp_g19_r2 pad gate iovss sub sg13_hv_nmos L=0.6u W=4.4u
Mclamp_g19_r3 pad gate iovss sub sg13_hv_nmos L=0.6u W=4.4u
Mclamp_g20_r0 iovss gate pad sub sg13_hv_nmos L=0.6u W=4.4u
Mclamp_g20_r1 iovss gate pad sub sg13_hv_nmos L=0.6u W=4.4u
Mclamp_g20_r2 iovss gate pad sub sg13_hv_nmos L=0.6u W=4.4u
Mclamp_g20_r3 iovss gate pad sub sg13_hv_nmos L=0.6u W=4.4u
Mclamp_g21_r0 pad gate iovss sub sg13_hv_nmos L=0.6u W=4.4u
Mclamp_g21_r1 pad gate iovss sub sg13_hv_nmos L=0.6u W=4.4u
Mclamp_g21_r2 pad gate iovss sub sg13_hv_nmos L=0.6u W=4.4u
Mclamp_g21_r3 pad gate iovss sub sg13_hv_nmos L=0.6u W=4.4u
Mclamp_g22_r0 iovss gate pad sub sg13_hv_nmos L=0.6u W=4.4u
Mclamp_g22_r1 iovss gate pad sub sg13_hv_nmos L=0.6u W=4.4u
Mclamp_g22_r2 iovss gate pad sub sg13_hv_nmos L=0.6u W=4.4u
Mclamp_g22_r3 iovss gate pad sub sg13_hv_nmos L=0.6u W=4.4u
Mclamp_g23_r0 pad gate iovss sub sg13_hv_nmos L=0.6u W=4.4u
Mclamp_g23_r1 pad gate iovss sub sg13_hv_nmos L=0.6u W=4.4u
Mclamp_g23_r2 pad gate iovss sub sg13_hv_nmos L=0.6u W=4.4u
Mclamp_g23_r3 pad gate iovss sub sg13_hv_nmos L=0.6u W=4.4u
Mclamp_g24_r0 iovss gate pad sub sg13_hv_nmos L=0.6u W=4.4u
Mclamp_g24_r1 iovss gate pad sub sg13_hv_nmos L=0.6u W=4.4u
Mclamp_g24_r2 iovss gate pad sub sg13_hv_nmos L=0.6u W=4.4u
Mclamp_g24_r3 iovss gate pad sub sg13_hv_nmos L=0.6u W=4.4u
Mclamp_g25_r0 pad gate iovss sub sg13_hv_nmos L=0.6u W=4.4u
Mclamp_g25_r1 pad gate iovss sub sg13_hv_nmos L=0.6u W=4.4u
Mclamp_g25_r2 pad gate iovss sub sg13_hv_nmos L=0.6u W=4.4u
Mclamp_g25_r3 pad gate iovss sub sg13_hv_nmos L=0.6u W=4.4u
Mclamp_g26_r0 iovss gate pad sub sg13_hv_nmos L=0.6u W=4.4u
Mclamp_g26_r1 iovss gate pad sub sg13_hv_nmos L=0.6u W=4.4u
Mclamp_g26_r2 iovss gate pad sub sg13_hv_nmos L=0.6u W=4.4u
Mclamp_g26_r3 iovss gate pad sub sg13_hv_nmos L=0.6u W=4.4u
Mclamp_g27_r0 pad gate iovss sub sg13_hv_nmos L=0.6u W=4.4u
Mclamp_g27_r1 pad gate iovss sub sg13_hv_nmos L=0.6u W=4.4u
Mclamp_g27_r2 pad gate iovss sub sg13_hv_nmos L=0.6u W=4.4u
Mclamp_g27_r3 pad gate iovss sub sg13_hv_nmos L=0.6u W=4.4u
Mclamp_g28_r0 iovss gate pad sub sg13_hv_nmos L=0.6u W=4.4u
Mclamp_g28_r1 iovss gate pad sub sg13_hv_nmos L=0.6u W=4.4u
Mclamp_g28_r2 iovss gate pad sub sg13_hv_nmos L=0.6u W=4.4u
Mclamp_g28_r3 iovss gate pad sub sg13_hv_nmos L=0.6u W=4.4u
Mclamp_g29_r0 pad gate iovss sub sg13_hv_nmos L=0.6u W=4.4u
Mclamp_g29_r1 pad gate iovss sub sg13_hv_nmos L=0.6u W=4.4u
Mclamp_g29_r2 pad gate iovss sub sg13_hv_nmos L=0.6u W=4.4u
Mclamp_g29_r3 pad gate iovss sub sg13_hv_nmos L=0.6u W=4.4u
Mclamp_g30_r0 iovss gate pad sub sg13_hv_nmos L=0.6u W=4.4u
Mclamp_g30_r1 iovss gate pad sub sg13_hv_nmos L=0.6u W=4.4u
Mclamp_g30_r2 iovss gate pad sub sg13_hv_nmos L=0.6u W=4.4u
Mclamp_g30_r3 iovss gate pad sub sg13_hv_nmos L=0.6u W=4.4u
Mclamp_g31_r0 pad gate iovss sub sg13_hv_nmos L=0.6u W=4.4u
Mclamp_g31_r1 pad gate iovss sub sg13_hv_nmos L=0.6u W=4.4u
Mclamp_g31_r2 pad gate iovss sub sg13_hv_nmos L=0.6u W=4.4u
Mclamp_g31_r3 pad gate iovss sub sg13_hv_nmos L=0.6u W=4.4u
Mclamp_g32_r0 iovss gate pad sub sg13_hv_nmos L=0.6u W=4.4u
Mclamp_g32_r1 iovss gate pad sub sg13_hv_nmos L=0.6u W=4.4u
Mclamp_g32_r2 iovss gate pad sub sg13_hv_nmos L=0.6u W=4.4u
Mclamp_g32_r3 iovss gate pad sub sg13_hv_nmos L=0.6u W=4.4u
Mclamp_g33_r0 pad gate iovss sub sg13_hv_nmos L=0.6u W=4.4u
Mclamp_g33_r1 pad gate iovss sub sg13_hv_nmos L=0.6u W=4.4u
Mclamp_g33_r2 pad gate iovss sub sg13_hv_nmos L=0.6u W=4.4u
Mclamp_g33_r3 pad gate iovss sub sg13_hv_nmos L=0.6u W=4.4u
Mclamp_g34_r0 iovss gate pad sub sg13_hv_nmos L=0.6u W=4.4u
Mclamp_g34_r1 iovss gate pad sub sg13_hv_nmos L=0.6u W=4.4u
Mclamp_g34_r2 iovss gate pad sub sg13_hv_nmos L=0.6u W=4.4u
Mclamp_g34_r3 iovss gate pad sub sg13_hv_nmos L=0.6u W=4.4u
Mclamp_g35_r0 pad gate iovss sub sg13_hv_nmos L=0.6u W=4.4u
Mclamp_g35_r1 pad gate iovss sub sg13_hv_nmos L=0.6u W=4.4u
Mclamp_g35_r2 pad gate iovss sub sg13_hv_nmos L=0.6u W=4.4u
Mclamp_g35_r3 pad gate iovss sub sg13_hv_nmos L=0.6u W=4.4u
Mclamp_g36_r0 iovss gate pad sub sg13_hv_nmos L=0.6u W=4.4u
Mclamp_g36_r1 iovss gate pad sub sg13_hv_nmos L=0.6u W=4.4u
Mclamp_g36_r2 iovss gate pad sub sg13_hv_nmos L=0.6u W=4.4u
Mclamp_g36_r3 iovss gate pad sub sg13_hv_nmos L=0.6u W=4.4u
Mclamp_g37_r0 pad gate iovss sub sg13_hv_nmos L=0.6u W=4.4u
Mclamp_g37_r1 pad gate iovss sub sg13_hv_nmos L=0.6u W=4.4u
Mclamp_g37_r2 pad gate iovss sub sg13_hv_nmos L=0.6u W=4.4u
Mclamp_g37_r3 pad gate iovss sub sg13_hv_nmos L=0.6u W=4.4u
Mclamp_g38_r0 iovss gate pad sub sg13_hv_nmos L=0.6u W=4.4u
Mclamp_g38_r1 iovss gate pad sub sg13_hv_nmos L=0.6u W=4.4u
Mclamp_g38_r2 iovss gate pad sub sg13_hv_nmos L=0.6u W=4.4u
Mclamp_g38_r3 iovss gate pad sub sg13_hv_nmos L=0.6u W=4.4u
Mclamp_g39_r0 pad gate iovss sub sg13_hv_nmos L=0.6u W=4.4u
Mclamp_g39_r1 pad gate iovss sub sg13_hv_nmos L=0.6u W=4.4u
Mclamp_g39_r2 pad gate iovss sub sg13_hv_nmos L=0.6u W=4.4u
Mclamp_g39_r3 pad gate iovss sub sg13_hv_nmos L=0.6u W=4.4u
Mclamp_g40_r0 iovss gate pad sub sg13_hv_nmos L=0.6u W=4.4u
Mclamp_g40_r1 iovss gate pad sub sg13_hv_nmos L=0.6u W=4.4u
Mclamp_g40_r2 iovss gate pad sub sg13_hv_nmos L=0.6u W=4.4u
Mclamp_g40_r3 iovss gate pad sub sg13_hv_nmos L=0.6u W=4.4u
Mclamp_g41_r0 pad gate iovss sub sg13_hv_nmos L=0.6u W=4.4u
Mclamp_g41_r1 pad gate iovss sub sg13_hv_nmos L=0.6u W=4.4u
Mclamp_g41_r2 pad gate iovss sub sg13_hv_nmos L=0.6u W=4.4u
Mclamp_g41_r3 pad gate iovss sub sg13_hv_nmos L=0.6u W=4.4u
Mclamp_g42_r0 iovss gate pad sub sg13_hv_nmos L=0.6u W=4.4u
Mclamp_g42_r1 iovss gate pad sub sg13_hv_nmos L=0.6u W=4.4u
Mclamp_g42_r2 iovss gate pad sub sg13_hv_nmos L=0.6u W=4.4u
Mclamp_g42_r3 iovss gate pad sub sg13_hv_nmos L=0.6u W=4.4u
XOuterRing iovdd sg13g2_GuardRing_N16000W4884HFF
XInnerRing iovss sg13g2_GuardRing_P15280W4164HFF
DDGATE sub gate dantenna A=0.2304p P=1.92u
Rtap0 iovss sub ptap1 A=65.6472p P=386.16u
.ends sg13g2_Clamp_N43N43D4R

* sg13g2_RCClampResistor
.subckt sg13g2_RCClampResistor pin1 pin2 sub
Rres_fing_0 pin1 conn_0_1 sub rppd l=20u w=1u
Rres_fing_1 conn_0_1 conn_1_2 sub rppd l=20u w=1u
Rres_fing_2 conn_1_2 conn_2_3 sub rppd l=20u w=1u
Rres_fing_3 conn_2_3 conn_3_4 sub rppd l=20u w=1u
Rres_fing_4 conn_3_4 conn_4_5 sub rppd l=20u w=1u
Rres_fing_5 conn_4_5 conn_5_6 sub rppd l=20u w=1u
Rres_fing_6 conn_5_6 conn_6_7 sub rppd l=20u w=1u
Rres_fing_7 conn_6_7 conn_7_8 sub rppd l=20u w=1u
Rres_fing_8 conn_7_8 conn_8_9 sub rppd l=20u w=1u
Rres_fing_9 conn_8_9 conn_9_10 sub rppd l=20u w=1u
Rres_fing_10 conn_9_10 conn_10_11 sub rppd l=20u w=1u
Rres_fing_11 conn_10_11 conn_11_12 sub rppd l=20u w=1u
Rres_fing_12 conn_11_12 conn_12_13 sub rppd l=20u w=1u
Rres_fing_13 conn_12_13 conn_13_14 sub rppd l=20u w=1u
Rres_fing_14 conn_13_14 conn_14_15 sub rppd l=20u w=1u
Rres_fing_15 conn_14_15 conn_15_16 sub rppd l=20u w=1u
Rres_fing_16 conn_15_16 conn_16_17 sub rppd l=20u w=1u
Rres_fing_17 conn_16_17 conn_17_18 sub rppd l=20u w=1u
Rres_fing_18 conn_17_18 conn_18_19 sub rppd l=20u w=1u
Rres_fing_19 conn_18_19 conn_19_20 sub rppd l=20u w=1u
Rres_fing_20 conn_19_20 conn_20_21 sub rppd l=20u w=1u
Rres_fing_21 conn_20_21 conn_21_22 sub rppd l=20u w=1u
Rres_fing_22 conn_21_22 conn_22_23 sub rppd l=20u w=1u
Rres_fing_23 conn_22_23 conn_23_24 sub rppd l=20u w=1u
Rres_fing_24 conn_23_24 conn_24_25 sub rppd l=20u w=1u
Rres_fing_25 conn_24_25 pin2 sub rppd l=20u w=1u
.ends sg13g2_RCClampResistor

* sg13g2_GuardRing_P16000W4466HFT
.subckt sg13g2_GuardRing_P16000W4466HFT conn

.ends sg13g2_GuardRing_P16000W4466HFT

* sg13g2_GuardRing_N9472W2216HTT
.subckt sg13g2_GuardRing_N9472W2216HTT conn

.ends sg13g2_GuardRing_N9472W2216HTT

* sg13g2_RCClampInverter
.subckt sg13g2_RCClampInverter supply iovss in out
Mcapmos0_r0 iovss in iovss sub sg13_hv_nmos L=9.5u W=9u
Mcapmos1_r0 iovss in iovss sub sg13_hv_nmos L=9.5u W=9u
Mcapmos2_r0 iovss in iovss sub sg13_hv_nmos L=9.5u W=9u
Mcapmos3_r0 iovss in iovss sub sg13_hv_nmos L=9.5u W=9u
Mcapmos4_r0 iovss in iovss sub sg13_hv_nmos L=9.5u W=9u
Mcapmos5_r0 iovss in iovss sub sg13_hv_nmos L=9.5u W=9u
Mcapmos6_r0 iovss in iovss sub sg13_hv_nmos L=9.5u W=9u
Mnmos0_r0 iovss in out sub sg13_hv_nmos L=0.5u W=9u
Mnmos1_r0 out in iovss sub sg13_hv_nmos L=0.5u W=9u
Mnmos2_r0 iovss in out sub sg13_hv_nmos L=0.5u W=9u
Mnmos3_r0 out in iovss sub sg13_hv_nmos L=0.5u W=9u
Mnmos4_r0 iovss in out sub sg13_hv_nmos L=0.5u W=9u
Mnmos5_r0 out in iovss sub sg13_hv_nmos L=0.5u W=9u
Mcapmos0_r1 iovss in iovss sub sg13_hv_nmos L=9.5u W=9u
Mcapmos1_r1 iovss in iovss sub sg13_hv_nmos L=9.5u W=9u
Mcapmos2_r1 iovss in iovss sub sg13_hv_nmos L=9.5u W=9u
Mcapmos3_r1 iovss in iovss sub sg13_hv_nmos L=9.5u W=9u
Mcapmos4_r1 iovss in iovss sub sg13_hv_nmos L=9.5u W=9u
Mcapmos5_r1 iovss in iovss sub sg13_hv_nmos L=9.5u W=9u
Mcapmos6_r1 iovss in iovss sub sg13_hv_nmos L=9.5u W=9u
Mnmos0_r1 iovss in out sub sg13_hv_nmos L=0.5u W=9u
Mnmos1_r1 out in iovss sub sg13_hv_nmos L=0.5u W=9u
Mnmos2_r1 iovss in out sub sg13_hv_nmos L=0.5u W=9u
Mnmos3_r1 out in iovss sub sg13_hv_nmos L=0.5u W=9u
Mnmos4_r1 iovss in out sub sg13_hv_nmos L=0.5u W=9u
Mnmos5_r1 out in iovss sub sg13_hv_nmos L=0.5u W=9u
Xnmosguardring iovss sg13g2_GuardRing_P16000W4466HFT
Mpmos0_r0 supply in out supply sg13_hv_pmos L=0.5u W=7u
Mpmos1_r0 out in supply supply sg13_hv_pmos L=0.5u W=7u
Mpmos2_r0 supply in out supply sg13_hv_pmos L=0.5u W=7u
Mpmos3_r0 out in supply supply sg13_hv_pmos L=0.5u W=7u
Mpmos4_r0 supply in out supply sg13_hv_pmos L=0.5u W=7u
Mpmos5_r0 out in supply supply sg13_hv_pmos L=0.5u W=7u
Mpmos6_r0 supply in out supply sg13_hv_pmos L=0.5u W=7u
Mpmos7_r0 out in supply supply sg13_hv_pmos L=0.5u W=7u
Mpmos8_r0 supply in out supply sg13_hv_pmos L=0.5u W=7u
Mpmos9_r0 out in supply supply sg13_hv_pmos L=0.5u W=7u
Mpmos10_r0 supply in out supply sg13_hv_pmos L=0.5u W=7u
Mpmos11_r0 out in supply supply sg13_hv_pmos L=0.5u W=7u
Mpmos12_r0 supply in out supply sg13_hv_pmos L=0.5u W=7u
Mpmos13_r0 out in supply supply sg13_hv_pmos L=0.5u W=7u
Mpmos14_r0 supply in out supply sg13_hv_pmos L=0.5u W=7u
Mpmos15_r0 out in supply supply sg13_hv_pmos L=0.5u W=7u
Mpmos16_r0 supply in out supply sg13_hv_pmos L=0.5u W=7u
Mpmos17_r0 out in supply supply sg13_hv_pmos L=0.5u W=7u
Mpmos18_r0 supply in out supply sg13_hv_pmos L=0.5u W=7u
Mpmos19_r0 out in supply supply sg13_hv_pmos L=0.5u W=7u
Mpmos20_r0 supply in out supply sg13_hv_pmos L=0.5u W=7u
Mpmos21_r0 out in supply supply sg13_hv_pmos L=0.5u W=7u
Mpmos22_r0 supply in out supply sg13_hv_pmos L=0.5u W=7u
Mpmos23_r0 out in supply supply sg13_hv_pmos L=0.5u W=7u
Mpmos24_r0 supply in out supply sg13_hv_pmos L=0.5u W=7u
Mpmos25_r0 out in supply supply sg13_hv_pmos L=0.5u W=7u
Mpmos26_r0 supply in out supply sg13_hv_pmos L=0.5u W=7u
Mpmos27_r0 out in supply supply sg13_hv_pmos L=0.5u W=7u
Mpmos28_r0 supply in out supply sg13_hv_pmos L=0.5u W=7u
Mpmos29_r0 out in supply supply sg13_hv_pmos L=0.5u W=7u
Mpmos30_r0 supply in out supply sg13_hv_pmos L=0.5u W=7u
Mpmos31_r0 out in supply supply sg13_hv_pmos L=0.5u W=7u
Mpmos32_r0 supply in out supply sg13_hv_pmos L=0.5u W=7u
Mpmos33_r0 out in supply supply sg13_hv_pmos L=0.5u W=7u
Mpmos34_r0 supply in out supply sg13_hv_pmos L=0.5u W=7u
Mpmos35_r0 out in supply supply sg13_hv_pmos L=0.5u W=7u
Mpmos36_r0 supply in out supply sg13_hv_pmos L=0.5u W=7u
Mpmos37_r0 out in supply supply sg13_hv_pmos L=0.5u W=7u
Mpmos38_r0 supply in out supply sg13_hv_pmos L=0.5u W=7u
Mpmos39_r0 out in supply supply sg13_hv_pmos L=0.5u W=7u
Mpmos40_r0 supply in out supply sg13_hv_pmos L=0.5u W=7u
Mpmos41_r0 out in supply supply sg13_hv_pmos L=0.5u W=7u
Mpmos42_r0 supply in out supply sg13_hv_pmos L=0.5u W=7u
Mpmos43_r0 out in supply supply sg13_hv_pmos L=0.5u W=7u
Mpmos44_r0 supply in out supply sg13_hv_pmos L=0.5u W=7u
Mpmos45_r0 out in supply supply sg13_hv_pmos L=0.5u W=7u
Mpmos46_r0 supply in out supply sg13_hv_pmos L=0.5u W=7u
Mpmos47_r0 out in supply supply sg13_hv_pmos L=0.5u W=7u
Mpmos48_r0 supply in out supply sg13_hv_pmos L=0.5u W=7u
Mpmos49_r0 out in supply supply sg13_hv_pmos L=0.5u W=7u
Xpmosguardring supply sg13g2_GuardRing_N9472W2216HTT
Rtap0 iovss sub ptap1 A=69.122p P=406.6u
.ends sg13g2_RCClampInverter

* sg13g2_GuardRing_N16000W6624HFF
.subckt sg13g2_GuardRing_N16000W6624HFF conn

.ends sg13g2_GuardRing_N16000W6624HFF

* sg13g2_IOPadIOVdd
* FITS TO SCH .subckt sg13g2_IOPadIOVdd vss vdd iovss iovdd
.subckt sg13g2_IOPadIOVdd iovdd iovss vdd vss
Xnclamp iovss iovdd iovdd ngate sg13g2_Clamp_N43N43D4R
Xrcres iovdd res_cap sub sg13g2_RCClampResistor
Xrcinv iovdd iovss res_cap ngate sg13g2_RCClampInverter
Xpad_guard iovss sg13g2_GuardRing_N16000W6624HFF
Rtap0 iovss sub ptap1 A=1997.9154p P=411.58u
Rtap1 vss sub ptap1 A=24p P=160.6u
.ends sg13g2_IOPadIOVdd
