* Extracted by KLayout with SG13G2 LVS runset on : 03/08/2026 14:20

.SUBCKT sg13g2_IOPadInOut30mA c2p c2p_en iovdd iovdd$1 iovss p2c pad vdd vss
X$1 iovdd$1 vdd vss \$5 \$27 c2p c2p_en \$1 sg13g2_GateDecode
X$2 \$1 iovss iovdd pad pad pad pad pad pad pad pad \$27 sg13g2_Clamp_P15N15D
X$3 \$1 iovss iovdd pad pad sg13g2_DCPDiode
X$4 \$1 iovss pad iovdd$1 vss p2c vdd sg13g2_LevelDown
X$5 \$1 iovss pad pad sg13g2_DCNDiode
X$6 \$1 iovss pad pad pad pad pad pad pad pad \$5 sg13g2_Clamp_N15N15D
R$1 iovss \$1 ptap1 A=4319.178p P=671.66u
R$2 vss \$1 ptap1 A=24p P=160.6u
.ENDS sg13g2_IOPadInOut30mA

.SUBCKT sg13g2_Clamp_N15N15D \$2 iovss pad pad$1 pad$2 pad$3 pad$4 pad$5 pad$6
+ pad$7 gate
M$1 iovss gate pad \$2 sg13_hv_nmos L=0.6u W=8.8u AS=4.664p AD=4.004p PS=15.32u
+ PD=10.62u rfmode=0
M$3 iovss gate pad$1 \$2 sg13_hv_nmos L=0.6u W=8.8u AS=4.004p AD=4.004p
+ PS=10.62u PD=10.62u rfmode=0
M$5 iovss gate pad$2 \$2 sg13_hv_nmos L=0.6u W=8.8u AS=4.004p AD=4.004p
+ PS=10.62u PD=10.62u rfmode=0
M$7 iovss gate pad$3 \$2 sg13_hv_nmos L=0.6u W=8.8u AS=4.004p AD=4.004p
+ PS=10.62u PD=10.62u rfmode=0
M$9 iovss gate pad$4 \$2 sg13_hv_nmos L=0.6u W=8.8u AS=4.004p AD=4.004p
+ PS=10.62u PD=10.62u rfmode=0
M$11 iovss gate pad$5 \$2 sg13_hv_nmos L=0.6u W=8.8u AS=4.004p AD=4.004p
+ PS=10.62u PD=10.62u rfmode=0
M$13 iovss gate pad$6 \$2 sg13_hv_nmos L=0.6u W=8.8u AS=4.004p AD=4.004p
+ PS=10.62u PD=10.62u rfmode=0
M$15 iovss gate pad$7 \$2 sg13_hv_nmos L=0.6u W=4.4u AS=1.408p AD=3.256p
+ PS=5.04u PD=10.28u rfmode=0
D$16 \$2 gate dantenna A=0.6084p P=3.12u m=1
R$17 iovss \$2 ptap1 A=55.7736p P=328.08u
.ENDS sg13g2_Clamp_N15N15D

.SUBCKT sg13g2_LevelDown \$1 iovss pad iovdd vss core vdd
X$1 \$1 iovss pad iovdd sg13g2_SecondaryProtection
M$1 core \$20 vss \$1 sg13_lv_nmos L=0.13u W=2.75u AS=0.935p AD=0.935p PS=6.18u
+ PD=6.18u rfmode=0
M$2 vss \$7 \$20 \$1 sg13_hv_nmos L=0.45u W=2.65u AS=0.901p AD=0.5035p PS=5.98u
+ PD=3.03u rfmode=0
M$3 \$20 \$6 vdd \$1 sg13_hv_nmos L=0.45u W=2.65u AS=0.5035p AD=0.901p PS=3.03u
+ PD=5.98u rfmode=0
M$4 \$6 pad iovss \$1 sg13_hv_nmos L=0.45u W=1.3u AS=0.442p AD=0.247p PS=3.28u
+ PD=1.68u rfmode=0
M$5 iovss \$6 \$7 \$1 sg13_hv_nmos L=0.45u W=1.3u AS=0.247p AD=0.442p PS=1.68u
+ PD=3.28u rfmode=0
M$6 core \$20 vdd vdd sg13_lv_pmos L=0.13u W=4.75u AS=1.615p AD=1.615p
+ PS=10.18u PD=10.18u rfmode=0
M$8 iovdd pad \$6 iovdd sg13_hv_pmos L=0.45u W=4.6u AS=1.219p AD=0.874p
+ PS=7.96u PD=5.36u rfmode=0
M$10 iovdd \$6 \$7 iovdd sg13_hv_pmos L=0.45u W=4.6u AS=0.874p AD=1.219p
+ PS=5.36u PD=7.96u rfmode=0
R$12 vss \$1 ptap1 A=2.019p P=14.06u
R$13 iovss \$1 ptap1 A=0.804p P=5.96u
.ENDS sg13g2_LevelDown

.SUBCKT sg13g2_DCPDiode \$1 guard cathode anode anode$1
D$1 anode$1 cathode dpantenna A=35.0028p P=58.08u m=1
D$2 anode cathode dpantenna A=35.0028p P=58.08u m=1
R$3 guard \$1 ptap1 A=33.5104p P=197.12u
.ENDS sg13g2_DCPDiode

.SUBCKT sg13g2_GateDecode iovdd vdd vss ngate pgate core en \$11
X$1 iovdd ngate \$11 \$7 vss vdd sg13g2_LevelUp
X$2 iovdd pgate \$11 \$6 vss vdd sg13g2_LevelUp
X$3 core \$8 \$7 vdd vss \$11 sg13g2_io_nor2_x1
X$4 vss \$11 sg13g2_io_tie
X$5 en vss \$8 vdd \$11 sg13g2_io_inv_x1
X$6 en vss core \$6 vdd \$11 sg13g2_io_nand2_x1
.ENDS sg13g2_GateDecode

.SUBCKT sg13g2_Clamp_P15N15D \$1 iovss iovdd pad pad$1 pad$2 pad$3 pad$4 pad$5
+ pad$6 pad$7 gate
M$1 iovdd gate pad iovdd sg13_hv_pmos L=0.6u W=26.64u AS=14.1192p AD=12.1212p
+ PS=44.2u PD=30.28u rfmode=0
M$3 iovdd gate pad$1 iovdd sg13_hv_pmos L=0.6u W=26.64u AS=12.1212p AD=12.1212p
+ PS=30.28u PD=30.28u rfmode=0
M$5 iovdd gate pad$2 iovdd sg13_hv_pmos L=0.6u W=26.64u AS=12.1212p AD=12.1212p
+ PS=30.28u PD=30.28u rfmode=0
M$7 iovdd gate pad$3 iovdd sg13_hv_pmos L=0.6u W=26.64u AS=12.1212p AD=12.1212p
+ PS=30.28u PD=30.28u rfmode=0
M$9 iovdd gate pad$4 iovdd sg13_hv_pmos L=0.6u W=26.64u AS=12.1212p AD=12.1212p
+ PS=30.28u PD=30.28u rfmode=0
M$11 iovdd gate pad$5 iovdd sg13_hv_pmos L=0.6u W=26.64u AS=12.1212p
+ AD=12.1212p PS=30.28u PD=30.28u rfmode=0
M$13 iovdd gate pad$6 iovdd sg13_hv_pmos L=0.6u W=26.64u AS=12.1212p
+ AD=12.1212p PS=30.28u PD=30.28u rfmode=0
M$15 iovdd gate pad$7 iovdd sg13_hv_pmos L=0.6u W=13.32u AS=4.2624p AD=9.8568p
+ PS=14.6u PD=29.6u rfmode=0
D$31 gate iovdd dpantenna A=0.6084p P=3.12u m=1
R$32 iovss \$1 ptap1 A=67.0344p P=394.32u
.ENDS sg13g2_Clamp_P15N15D

.SUBCKT sg13g2_DCNDiode \$2 anode cathode cathode$1
D$1 \$2 cathode$1 dantenna A=35.0028p P=58.08u m=1
D$2 \$2 cathode dantenna A=35.0028p P=58.08u m=1
R$3 anode \$2 ptap1 A=141.2964p P=221.76u
.ENDS sg13g2_DCNDiode

.SUBCKT sg13g2_SecondaryProtection \$1 minus core|pad plus
D$1 \$1 core|pad dantenna A=1.984p P=7.48u m=1
D$2 core|pad plus dpantenna A=3.1872p P=11.24u m=1
R$3 minus \$1 ptap1 A=9.0304p P=53.12u
.ENDS sg13g2_SecondaryProtection

.SUBCKT sg13g2_io_nand2_x1 i1 vss i0 nq vdd \$6
M$1 vss i0 \$8 \$6 sg13_lv_nmos L=0.13u W=3.93u AS=1.3362p AD=0.7467p PS=8.54u
+ PD=4.31u rfmode=0
M$2 \$8 i1 nq \$6 sg13_lv_nmos L=0.13u W=3.93u AS=0.7467p AD=1.4148p PS=4.31u
+ PD=8.58u rfmode=0
M$3 vdd i0 nq vdd sg13_lv_pmos L=0.13u W=4.41u AS=1.4994p AD=0.8379p PS=9.5u
+ PD=4.79u rfmode=0
M$4 nq i1 vdd vdd sg13_lv_pmos L=0.13u W=4.41u AS=0.8379p AD=1.5876p PS=4.79u
+ PD=9.54u rfmode=0
R$5 vss \$6 ptap1 A=0.657p P=4.98u
.ENDS sg13g2_io_nand2_x1

.SUBCKT sg13g2_io_tie vss \$3
R$1 vss \$3 ptap1 A=0.6255p P=4.77u
.ENDS sg13g2_io_tie

.SUBCKT sg13g2_io_nor2_x1 i0 i1 nq vdd vss \$6
M$1 vss i0 nq \$6 sg13_lv_nmos L=0.13u W=3.93u AS=1.3362p AD=0.7467p PS=8.54u
+ PD=4.31u rfmode=0
M$2 nq i1 vss \$6 sg13_lv_nmos L=0.13u W=3.93u AS=0.7467p AD=1.4148p PS=4.31u
+ PD=8.58u rfmode=0
M$3 vdd i0 \$8 vdd sg13_lv_pmos L=0.13u W=4.41u AS=1.4994p AD=0.8379p PS=9.5u
+ PD=4.79u rfmode=0
M$4 \$8 i1 nq vdd sg13_lv_pmos L=0.13u W=4.41u AS=0.8379p AD=1.5876p PS=4.79u
+ PD=9.54u rfmode=0
R$5 vss \$6 ptap1 A=0.657p P=4.98u
.ENDS sg13g2_io_nor2_x1

.SUBCKT sg13g2_LevelUp iovdd o \$5 i vss vdd
M$1 \$6 i vss \$5 sg13_lv_nmos L=0.13u W=2.75u AS=0.935p AD=0.935p PS=6.18u
+ PD=6.18u rfmode=0
M$2 vss \$4 o \$5 sg13_hv_nmos L=0.45u W=1.9u AS=0.646p AD=0.646p PS=4.48u
+ PD=4.48u rfmode=0
M$3 \$3 \$6 vss \$5 sg13_hv_nmos L=0.45u W=1.9u AS=0.646p AD=0.361p PS=4.48u
+ PD=2.28u rfmode=0
M$4 vss i \$4 \$5 sg13_hv_nmos L=0.45u W=1.9u AS=0.361p AD=0.646p PS=2.28u
+ PD=4.48u rfmode=0
M$5 \$6 i vdd vdd sg13_lv_pmos L=0.13u W=4.75u AS=1.615p AD=1.615p PS=10.18u
+ PD=10.18u rfmode=0
M$6 iovdd \$4 o iovdd sg13_hv_pmos L=0.45u W=3.9u AS=1.326p AD=1.326p PS=8.48u
+ PD=8.48u rfmode=0
M$7 \$3 \$4 iovdd iovdd sg13_hv_pmos L=0.45u W=0.3u AS=0.102p AD=0.057p
+ PS=1.28u PD=0.68u rfmode=0
M$8 iovdd \$3 \$4 iovdd sg13_hv_pmos L=0.45u W=0.3u AS=0.057p AD=0.102p
+ PS=0.68u PD=1.28u rfmode=0
R$9 vss \$5 ptap1 A=0.9135p P=6.69u
.ENDS sg13g2_LevelUp

.SUBCKT sg13g2_io_inv_x1 i vss nq vdd \$5
M$1 vss i nq \$5 sg13_lv_nmos L=0.13u W=3.93u AS=1.3362p AD=1.3362p PS=8.54u
+ PD=8.54u rfmode=0
M$2 vdd i nq vdd sg13_lv_pmos L=0.13u W=4.41u AS=1.4994p AD=1.4994p PS=9.5u
+ PD=9.5u rfmode=0
R$3 vss \$5 ptap1 A=0.624p P=4.76u
.ENDS sg13g2_io_inv_x1
