* Extracted by KLayout with SG13G2 LVS runset on : 03/08/2026 14:09

.SUBCKT sg13g2_IOPadInOut30mA anode|cathode|core|pad anode|guard|iovss|minus
+ c2p|core|i0 c2p_en|en|i|i1 cathode|iovdd core|p2c gate|ngate|o gate|o|pgate
+ i|nq i|nq$1 i1|nq iovdd|plus vdd vss
M$1 vss c2p_en|en|i|i1 i1|nq \$1 sg13_lv_nmos L=0.13u W=3.93u AS=1.3362p
+ AD=1.3362p PS=8.54u PD=8.54u rfmode=0
M$2 vss c2p|core|i0 \$56 \$1 sg13_lv_nmos L=0.13u W=3.93u AS=1.3362p AD=0.7467p
+ PS=8.54u PD=4.31u rfmode=0
M$3 \$56 c2p_en|en|i|i1 i|nq$1 \$1 sg13_lv_nmos L=0.13u W=3.93u AS=0.7467p
+ AD=1.4148p PS=4.31u PD=8.58u rfmode=0
M$4 vss c2p|core|i0 i|nq \$1 sg13_lv_nmos L=0.13u W=3.93u AS=1.3362p AD=0.7467p
+ PS=8.54u PD=4.31u rfmode=0
M$5 i|nq i1|nq vss \$1 sg13_lv_nmos L=0.13u W=3.93u AS=0.7467p AD=1.4148p
+ PS=4.31u PD=8.58u rfmode=0
M$6 core|p2c \$45 vss \$1 sg13_lv_nmos L=0.13u W=2.75u AS=0.935p AD=0.935p
+ PS=6.18u PD=6.18u rfmode=0
M$7 \$42 i|nq$1 vss \$1 sg13_lv_nmos L=0.13u W=2.75u AS=0.935p AD=0.935p
+ PS=6.18u PD=6.18u rfmode=0
M$8 \$40 i|nq vss \$1 sg13_lv_nmos L=0.13u W=2.75u AS=0.935p AD=0.935p PS=6.18u
+ PD=6.18u rfmode=0
M$9 vss \$31 \$45 \$1 sg13_hv_nmos L=0.45u W=2.65u AS=0.901p AD=0.5035p
+ PS=5.98u PD=3.03u rfmode=0
M$10 \$45 \$23 vdd \$1 sg13_hv_nmos L=0.45u W=2.65u AS=0.5035p AD=0.901p
+ PS=3.03u PD=5.98u rfmode=0
M$11 anode|guard|iovss|minus gate|ngate|o anode|cathode|core|pad \$1
+ sg13_hv_nmos L=0.6u W=66u AS=30.096p AD=31.284p PS=84.08u PD=84.62u rfmode=0
M$26 \$35 \$40 vss \$1 sg13_hv_nmos L=0.45u W=1.9u AS=0.646p AD=0.361p PS=4.48u
+ PD=2.28u rfmode=0
M$27 vss i|nq \$36 \$1 sg13_hv_nmos L=0.45u W=1.9u AS=0.361p AD=0.646p PS=2.28u
+ PD=4.48u rfmode=0
M$28 \$37 \$42 vss \$1 sg13_hv_nmos L=0.45u W=1.9u AS=0.646p AD=0.361p PS=4.48u
+ PD=2.28u rfmode=0
M$29 vss i|nq$1 \$38 \$1 sg13_hv_nmos L=0.45u W=1.9u AS=0.361p AD=0.646p
+ PS=2.28u PD=4.48u rfmode=0
M$30 \$23 anode|cathode|core|pad anode|guard|iovss|minus \$1 sg13_hv_nmos
+ L=0.45u W=1.3u AS=0.442p AD=0.247p PS=3.28u PD=1.68u rfmode=0
M$31 anode|guard|iovss|minus \$23 \$31 \$1 sg13_hv_nmos L=0.45u W=1.3u
+ AS=0.247p AD=0.442p PS=1.68u PD=3.28u rfmode=0
M$32 vss \$36 gate|ngate|o \$1 sg13_hv_nmos L=0.45u W=1.9u AS=0.646p AD=0.646p
+ PS=4.48u PD=4.48u rfmode=0
M$33 vss \$38 gate|o|pgate \$1 sg13_hv_nmos L=0.45u W=1.9u AS=0.646p AD=0.646p
+ PS=4.48u PD=4.48u rfmode=0
M$34 vdd c2p_en|en|i|i1 i1|nq vdd sg13_lv_pmos L=0.13u W=4.41u AS=1.4994p
+ AD=1.4994p PS=9.5u PD=9.5u rfmode=0
M$35 vdd c2p|core|i0 \$57 vdd sg13_lv_pmos L=0.13u W=4.41u AS=1.4994p
+ AD=0.8379p PS=9.5u PD=4.79u rfmode=0
M$36 \$57 i1|nq i|nq vdd sg13_lv_pmos L=0.13u W=4.41u AS=0.8379p AD=1.5876p
+ PS=4.79u PD=9.54u rfmode=0
M$37 vdd c2p|core|i0 i|nq$1 vdd sg13_lv_pmos L=0.13u W=4.41u AS=1.4994p
+ AD=0.8379p PS=9.5u PD=4.79u rfmode=0
M$38 i|nq$1 c2p_en|en|i|i1 vdd vdd sg13_lv_pmos L=0.13u W=4.41u AS=0.8379p
+ AD=1.5876p PS=4.79u PD=9.54u rfmode=0
M$39 core|p2c \$45 vdd vdd sg13_lv_pmos L=0.13u W=4.75u AS=1.615p AD=1.615p
+ PS=10.18u PD=10.18u rfmode=0
M$40 \$42 i|nq$1 vdd vdd sg13_lv_pmos L=0.13u W=4.75u AS=1.615p AD=1.615p
+ PS=10.18u PD=10.18u rfmode=0
M$41 \$40 i|nq vdd vdd sg13_lv_pmos L=0.13u W=4.75u AS=1.615p AD=1.615p
+ PS=10.18u PD=10.18u rfmode=0
M$42 cathode|iovdd gate|o|pgate anode|cathode|core|pad cathode|iovdd
+ sg13_hv_pmos L=0.6u W=199.8u AS=91.1088p AD=94.7052p PS=240.48u PD=241.56u
+ rfmode=0
M$72 \$35 \$36 iovdd|plus iovdd|plus sg13_hv_pmos L=0.45u W=0.3u AS=0.102p
+ AD=0.057p PS=1.28u PD=0.68u rfmode=0
M$73 iovdd|plus \$35 \$36 iovdd|plus sg13_hv_pmos L=0.45u W=0.3u AS=0.057p
+ AD=0.102p PS=0.68u PD=1.28u rfmode=0
M$74 iovdd|plus \$36 gate|ngate|o iovdd|plus sg13_hv_pmos L=0.45u W=3.9u
+ AS=1.326p AD=1.326p PS=8.48u PD=8.48u rfmode=0
M$75 \$37 \$38 iovdd|plus iovdd|plus sg13_hv_pmos L=0.45u W=0.3u AS=0.102p
+ AD=0.057p PS=1.28u PD=0.68u rfmode=0
M$76 iovdd|plus \$37 \$38 iovdd|plus sg13_hv_pmos L=0.45u W=0.3u AS=0.057p
+ AD=0.102p PS=0.68u PD=1.28u rfmode=0
M$77 iovdd|plus \$38 gate|o|pgate iovdd|plus sg13_hv_pmos L=0.45u W=3.9u
+ AS=1.326p AD=1.326p PS=8.48u PD=8.48u rfmode=0
M$79 iovdd|plus anode|cathode|core|pad \$23 iovdd|plus sg13_hv_pmos L=0.45u
+ W=4.6u AS=1.219p AD=0.874p PS=7.96u PD=5.36u rfmode=0
M$81 iovdd|plus \$23 \$31 iovdd|plus sg13_hv_pmos L=0.45u W=4.6u AS=0.874p
+ AD=1.219p PS=5.36u PD=7.96u rfmode=0
D$83 \$1 anode|cathode|core|pad dantenna A=1.984p P=7.48u m=1
D$84 \$1 anode|cathode|core|pad dantenna A=35.0028p P=58.08u m=2
D$86 \$1 gate|ngate|o dantenna A=0.6084p P=3.12u m=1
D$87 anode|cathode|core|pad iovdd|plus dpantenna A=3.1872p P=11.24u m=1
D$88 gate|o|pgate cathode|iovdd dpantenna A=0.6084p P=3.12u m=1
D$89 anode|cathode|core|pad cathode|iovdd dpantenna A=35.0028p P=58.08u m=2
R$91 anode|guard|iovss|minus \$1 ptap1 A=4620.8492p P=1546.54u
R$94 vss \$1 ptap1 A=26.3625p P=177.55u
.ENDS sg13g2_IOPadInOut30mA
